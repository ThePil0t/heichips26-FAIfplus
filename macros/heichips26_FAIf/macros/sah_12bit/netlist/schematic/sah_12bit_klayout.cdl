** sch_path: /home/benedikt/heichips26-FAIf/macros/heichips26_FAIf/macros/sah_12bit/schematic/xschem/sah_12bit.sch
.subckt sah_12bit VDD SH_IN SH_OUT SH_EN VSS
*.PININFO SH_IN:I SH_EN:I SH_OUT:O VDD:B VSS:B
MMN1 SH_IN sw SH_OUT VSS sg13_hv_nmos w=0.6u l=0.45u ng=2
MMP1 SH_IN sw_b SH_OUT VDD sg13_hv_pmos w=1.8u l=0.45u ng=2
MMND1 SH_IN sw_b SH_IN VSS sg13_hv_nmos w=0.3u l=0.45u ng=1
MMPD1 SH_IN sw_d SH_IN VDD sg13_hv_pmos w=0.9u l=0.45u ng=1
MMND2 SH_OUT sw_b SH_OUT VSS sg13_hv_nmos w=0.3u l=0.45u ng=1
MMPD2 SH_OUT sw_d SH_OUT VDD sg13_hv_pmos w=0.9u l=0.45u ng=1
MMPI1 sw_n SH_EN VDD VDD sg13_hv_pmos w=1.2u l=0.45u ng=1
MMNI1 sw_n SH_EN VSS VSS sg13_hv_nmos w=0.6u l=0.45u ng=1
MMPI2 sw sw_n VDD VDD sg13_hv_pmos w=1.2u l=0.45u ng=1
MMNI2 sw sw_n VSS VSS sg13_hv_nmos w=0.6u l=0.45u ng=1
MMPI3 sw_b sw VDD VDD sg13_hv_pmos w=1.2u l=0.45u ng=1 m=2
MMNI3 sw_b sw VSS VSS sg13_hv_nmos w=0.6u l=0.45u ng=1 m=2
MMPI4 sw_d sw_b VDD VDD sg13_hv_pmos w=1.2u l=0.45u ng=1 m=2
MMNI4 sw_d sw_b VSS VSS sg13_hv_nmos w=0.6u l=0.45u ng=1 m=2
CC1 SH_OUT VSS cap_cmomi w=54.29e-6 l=27.72e-6
.ends
