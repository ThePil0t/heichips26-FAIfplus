* sah_12bit post-layout netlist (hybrid), generated by scripts/layout/hybrid_pex.py
* Magic C(SH_OUT,VSS): bare cap 1477.7 fF, shielded cap 1716.3 fF; model C1 1213.8 fF -> cap environment 196.0 fF
.subckt sah_12bit_pex VDD SH_IN SH_OUT SH_EN VSS CW=54.29e-6 CL=27.72e-6
XMN1 SH_IN sw SH_OUT VSS sg13_hv_nmos w=0.6u l=0.45u ng=2 m=1 as=0.114p ad=0.159p ps=1.36u pd=1.96u
XMP1 SH_IN sw_b SH_OUT VDD sg13_hv_pmos w=1.8u l=0.45u ng=2 m=1 as=0.342p ad=0.477p ps=2.56u pd=3.76u
XMND1 SH_IN sw_b SH_IN VSS sg13_hv_nmos w=0.3u l=0.45u ng=1 m=1 as=0.102p ad=0.057p ps=1.28u pd=0.68u
XMPD1 SH_IN sw_d SH_IN VDD sg13_hv_pmos w=0.9u l=0.45u ng=1 m=1 as=0.306p ad=0.171p ps=2.48u pd=1.28u
XMND2 SH_OUT sw_b SH_OUT VSS sg13_hv_nmos w=0.3u l=0.45u ng=1 m=1 as=0.057p ad=0.057p ps=0.68u pd=0.68u
XMPD2 SH_OUT sw_d SH_OUT VDD sg13_hv_pmos w=0.9u l=0.45u ng=1 m=1 as=0.171p ad=0.171p ps=1.28u pd=1.28u
XMPI1 sw_n SH_EN VDD VDD sg13_hv_pmos w=1.2u l=0.45u ng=1 m=1
XMNI1 sw_n SH_EN VSS VSS sg13_hv_nmos w=0.6u l=0.45u ng=1 m=1
XMPI2 sw sw_n VDD VDD sg13_hv_pmos w=1.2u l=0.45u ng=1 m=1
XMNI2 sw sw_n VSS VSS sg13_hv_nmos w=0.6u l=0.45u ng=1 m=1
XMPI3 sw_b sw VDD VDD sg13_hv_pmos w=1.2u l=0.45u ng=1 m=2
XMNI3 sw_b sw VSS VSS sg13_hv_nmos w=0.6u l=0.45u ng=1 m=2
XMPI4 sw_d sw_b VDD VDD sg13_hv_pmos w=1.2u l=0.45u ng=1 m=2
XMNI4 sw_d sw_b VSS VSS sg13_hv_nmos w=0.6u l=0.45u ng=1 m=2
XC1 SH_OUT VSS cap_cmomi w={CW} l={CL} mmin=1 mmax=3 feed=double subblock=0 m=1 mm_ok=1
* wire parasitics (Magic, C-coupled, layout without the cap and its shield box)
Cw0 sw_b VDD 1.23419f
Cw1 VDD sw_d 0.65242f
Cw2 VDD SH_IN 0.63951f
Cw3 VDD SH_OUT 0.09653f
Cw4 sw_n SH_EN 0.20873f
Cw5 sw_n sw 0.24496f
Cw6 sw_b sw_d 2.16246f
Cw7 sw_b SH_IN 1.26947f
Cw8 sw_b SH_OUT 0.36269f
Cw9 SH_EN VDD 0.26560f
Cw10 VDD sw 1.13337f
Cw11 sw_d SH_IN 0.25272f
Cw12 sw_d SH_OUT 0.16731f
Cw13 SH_IN SH_OUT 0.35548f
Cw14 sw_n VDD 0.44943f
Cw15 sw_b sw 0.90102f
Cw16 sw_d sw 0.17208f
Cw17 sw SH_IN 0.88483f
Cw18 sw SH_OUT 0.20885f
Cw19 SH_OUT VSS 14.21874f
Cw20 SH_IN VSS 7.50658f
Cw21 VDD VSS 1.90854f
Cenv SH_OUT VSS 196.043f
.ends
