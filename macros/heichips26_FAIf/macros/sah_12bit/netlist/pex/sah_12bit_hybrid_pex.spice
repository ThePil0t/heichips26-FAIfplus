* sah_12bit post-layout netlist (hybrid), generated by scripts/layout/hybrid_pex.py
* Magic C(SH_OUT,VSS): bare cap 1477.7 fF, shielded cap 1716.4 fF; model C1 1213.8 fF -> cap environment 196.1 fF
.subckt sah_12bit_pex VDD SH_IN SH_OUT SH_EN VSS CW=54.29e-6 CL=27.72e-6
XMN1 SH_IN sw SH_OUT VSS sg13_hv_nmos w=0.6u l=0.45u ng=2 m=1 as=0.114p ad=0.159p ps=1.36u pd=1.96u
XMP1 SH_IN sw_b SH_OUT VDD sg13_hv_pmos w=1.8u l=0.45u ng=2 m=1 as=0.342p ad=0.477p ps=2.56u pd=3.76u
XMND1 SH_IN sw_b SH_IN VSS sg13_hv_nmos w=0.3u l=0.45u ng=1 m=1 as=0.102p ad=0.057p ps=1.28u pd=0.68u
XMPD1 SH_IN sw_d SH_IN VDD sg13_hv_pmos w=0.9u l=0.45u ng=1 m=1 as=0.306p ad=0.171p ps=2.48u pd=1.28u
XMND2 SH_OUT sw_b SH_OUT VSS sg13_hv_nmos w=0.3u l=0.45u ng=1 m=1 as=0.057p ad=0.057p ps=0.68u pd=0.68u
XMPD2 SH_OUT sw_d SH_OUT VDD sg13_hv_pmos w=0.9u l=0.45u ng=1 m=1 as=0.171p ad=0.171p ps=1.28u pd=1.28u
XMPI1 sw_n SH_EN VDD VDD sg13_hv_pmos w=1.2u l=0.45u ng=1 m=1
XMNI1 sw_n SH_EN VSS VSS sg13_hv_nmos w=0.6u l=0.45u ng=1 m=1
XMPI2 sw sw_n VDD VDD sg13_hv_pmos w=1.2u l=0.45u ng=1 m=1
XMNI2 sw sw_n VSS VSS sg13_hv_nmos w=0.6u l=0.45u ng=1 m=1
XMPI3 sw_b sw VDD VDD sg13_hv_pmos w=1.2u l=0.45u ng=1 m=2
XMNI3 sw_b sw VSS VSS sg13_hv_nmos w=0.6u l=0.45u ng=1 m=2
XMPI4 sw_d sw_b VDD VDD sg13_hv_pmos w=1.2u l=0.45u ng=1 m=2
XMNI4 sw_d sw_b VSS VSS sg13_hv_nmos w=0.6u l=0.45u ng=1 m=2
XC1 SH_OUT VSS cap_cmomi w={CW} l={CL} mmin=1 mmax=3 feed=double subblock=0 m=1 mm_ok=1
* wire parasitics (Magic, C-coupled, layout without the cap and its shield box)
Cw0 sw_n sw 0.27217f
Cw1 sw VDD 0.91196f
Cw2 sw_b sw_d 3.37412f
Cw3 sw SH_IN 0.67855f
Cw4 sw_b SH_OUT 0.33260f
Cw5 VSS VDD 0.08854f
Cw6 VSS SH_IN 2.48811f
Cw7 sw_d VDD 0.77209f
Cw8 SH_OUT VDD 0.05322f
Cw9 sw_d SH_IN 0.47940f
Cw10 SH_OUT SH_IN 0.34707f
Cw11 sw_b VDD 1.26765f
Cw12 VSS sw 0.01084f
Cw13 VSS SH_OUT 0.60306f
Cw14 sw_n SH_EN 0.23232f
Cw15 sw_b SH_IN 0.92169f
Cw16 VDD SH_EN 0.20006f
Cw17 sw_d sw 0.06074f
Cw18 sw_n VDD 0.44965f
Cw19 SH_OUT sw 0.20908f
Cw20 SH_IN VDD 0.70989f
Cw21 SH_OUT VSS 0.02701f
Cw22 sw_b sw 2.81372f
Cw23 VSS VDD 0.03034f
Cw24 sw SH_EN 0.07377f
Cw25 VSS SH_IN 0.05142f
Cw26 sw_b VSS 0.01054f
Cw27 SH_OUT sw_d 0.16321f
Cw28 SH_OUT VSS 2.42331f
Cw29 SH_IN VSS 5.15202f
Cw30 VDD VSS 2.97770f
Cenv SH_OUT VSS 196.100f
.ends
