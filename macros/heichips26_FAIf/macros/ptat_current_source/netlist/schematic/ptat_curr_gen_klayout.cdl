** sch_path: /home/benedikt/heichips26-FAIf/macros/heichips26_FAIf/macros/ptat_current_source/schematic/xschem/ptat_curr_gen.sch
.subckt ptat_curr_gen PCSVDD CSOUT1 CSOUT2 CSOUT3 PBIAS PCSVSS CSOUT4
*.PININFO PCSVDD:B PCSVSS:B CSOUT1:O CSOUT2:O CSOUT3:O PBIAS:O CSOUT4:O
MM1 net1 net1 PCSVSS PCSVSS sg13_hv_nmos w=2u l=2u ng=1
MM2 PBIAS net1 res_tap PCSVSS sg13_hv_nmos w=10u l=2u ng=1
MM3 net1 PBIAS PCSVDD PCSVDD sg13_hv_pmos w=0.4u l=1u ng=1
MM4 PBIAS PBIAS PCSVDD PCSVDD sg13_hv_pmos w=0.4u l=1u ng=1
RR1 res_tap PCSVSS 1.9937MEG $SUB=PCSVSS $[rhigh] w=0.5e-6 l=31.135e-6 ps=0.18e-6 b=21
MM5 CSOUT3 PBIAS PCSVDD PCSVDD sg13_hv_pmos w=0.4u l=1u ng=1
MM6 CSOUT2 PBIAS PCSVDD PCSVDD sg13_hv_pmos w=0.4u l=1u ng=1
MM7 CSOUT1 PBIAS PCSVDD PCSVDD sg13_hv_pmos w=0.4u l=1u ng=1
MMD1 PCSVSS PCSVSS PCSVSS PCSVSS sg13_hv_nmos w=10u l=2u ng=1
MMD2 PCSVSS PCSVSS PCSVSS PCSVSS sg13_hv_nmos w=10u l=2u ng=1
MMD3 PCSVSS PCSVSS PCSVSS PCSVSS sg13_hv_nmos w=5u l=2u ng=1
MMD4 PCSVSS PCSVSS PCSVSS PCSVSS sg13_hv_nmos w=5u l=2u ng=1
MMD5 PCSVSS PCSVSS PCSVSS PCSVSS sg13_hv_nmos w=5u l=2u ng=1
MMD6 PCSVSS PCSVSS PCSVSS PCSVSS sg13_hv_nmos w=5u l=2u ng=1
MMD7 PCSVSS PCSVSS PCSVSS PCSVSS sg13_hv_nmos w=5u l=2u ng=1
MMD8 PCSVSS PCSVSS PCSVSS PCSVSS sg13_hv_nmos w=5u l=2u ng=1
MMD9 PCSVSS PCSVSS PCSVSS PCSVSS sg13_hv_nmos w=2u l=2u ng=1
MMD10 PCSVSS PCSVSS PCSVSS PCSVSS sg13_hv_nmos w=2u l=2u ng=1
MMD11 PCSVSS PCSVSS PCSVSS PCSVSS sg13_hv_nmos w=1u l=2u ng=1
MMD12 PCSVSS PCSVSS PCSVSS PCSVSS sg13_hv_nmos w=1u l=2u ng=1
MMD13 PCSVSS PCSVSS PCSVSS PCSVSS sg13_hv_nmos w=1u l=2u ng=1
MMD14 PCSVSS PCSVSS PCSVSS PCSVSS sg13_hv_nmos w=1u l=2u ng=1
MMD15 PCSVSS PCSVSS PCSVSS PCSVSS sg13_hv_nmos w=1u l=2u ng=1
MMD16 PCSVSS PCSVSS PCSVSS PCSVSS sg13_hv_nmos w=1u l=2u ng=1
MMD17 PCSVDD PCSVDD PCSVDD PCSVDD sg13_hv_pmos w=0.4u l=1u ng=1
MMD24 PCSVDD PCSVDD PCSVDD PCSVDD sg13_hv_pmos w=0.4u l=1u ng=1
MMD31 PCSVDD PCSVDD PCSVDD PCSVDD sg13_hv_pmos w=0.4u l=1u ng=1
MMD18 PCSVDD PCSVDD PCSVDD PCSVDD sg13_hv_pmos w=0.4u l=1u ng=1
MMD19 PCSVDD PCSVDD PCSVDD PCSVDD sg13_hv_pmos w=0.4u l=1u ng=1
MMD20 PCSVDD PCSVDD PCSVDD PCSVDD sg13_hv_pmos w=0.4u l=1u ng=1
MMD21 PCSVDD PCSVDD PCSVDD PCSVDD sg13_hv_pmos w=0.4u l=1u ng=1
MMD22 PCSVDD PCSVDD PCSVDD PCSVDD sg13_hv_pmos w=0.4u l=1u ng=1
MMD23 PCSVDD PCSVDD PCSVDD PCSVDD sg13_hv_pmos w=0.4u l=1u ng=1
MMD25 PCSVDD PCSVDD PCSVDD PCSVDD sg13_hv_pmos w=0.4u l=1u ng=1
MMD26 PCSVDD PCSVDD PCSVDD PCSVDD sg13_hv_pmos w=0.4u l=1u ng=1
MMD27 PCSVDD PCSVDD PCSVDD PCSVDD sg13_hv_pmos w=0.4u l=1u ng=1
MMD28 PCSVDD PCSVDD PCSVDD PCSVDD sg13_hv_pmos w=0.4u l=1u ng=1
MMD29 PCSVDD PCSVDD PCSVDD PCSVDD sg13_hv_pmos w=0.4u l=1u ng=1
MMD30 PCSVDD PCSVDD PCSVDD PCSVDD sg13_hv_pmos w=0.4u l=1u ng=1
MMD32 PCSVDD PCSVDD PCSVDD PCSVDD sg13_hv_pmos w=0.4u l=1u ng=1
MMD33 PCSVDD PCSVDD PCSVDD PCSVDD sg13_hv_pmos w=0.4u l=1u ng=1
MMD34 PCSVDD PCSVDD PCSVDD PCSVDD sg13_hv_pmos w=0.4u l=1u ng=1
MMD35 PCSVDD PCSVDD PCSVDD PCSVDD sg13_hv_pmos w=0.4u l=1u ng=1
MMD36 PCSVDD PCSVDD PCSVDD PCSVDD sg13_hv_pmos w=0.4u l=1u ng=1
MMS1 CSSTARTUP PBIAS PCSVDD PCSVDD sg13_hv_pmos w=0.4u l=1u ng=1
MMS3 PCSVSS CSSTARTUP PBIAS PCSVDD sg13_hv_pmos w=0.4u l=1u ng=1
MMSS5 wcs4 wcs4 CSSTARTUP CSSTARTUP sg13_hv_pmos w=0.3u l=3u ng=1
MM8 CSOUT4 PBIAS PCSVDD PCSVDD sg13_hv_pmos w=0.4u l=1u ng=1
MMSS4 wcs3 wcs3 wcs4 wcs4 sg13_hv_pmos w=0.3u l=3u ng=1
MMSS3 wcs2 wcs2 wcs3 wcs3 sg13_hv_pmos w=0.3u l=3u ng=1
MMSS2 wcs1 wcs1 wcs2 wcs2 sg13_hv_pmos w=0.3u l=3u ng=1
MMSS1 PCSVSS PCSVSS wcs1 wcs1 sg13_hv_pmos w=0.3u l=3u ng=1
MMD37 PCSVDD PCSVDD PCSVDD PCSVDD sg13_hv_pmos w=0.4u l=1u ng=1
MMD38 PCSVDD PCSVDD PCSVDD PCSVDD sg13_hv_pmos w=0.4u l=1u ng=1
MMD39 PCSVDD PCSVDD PCSVDD PCSVDD sg13_hv_pmos w=0.3u l=3u ng=1
MMD40 PCSVDD PCSVDD PCSVDD PCSVDD sg13_hv_pmos w=0.3u l=3u ng=1
.ends
