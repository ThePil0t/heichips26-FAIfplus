* Extracted by KLayout with SG13CMOS5L LVS runset on : 09/10/2026 01:07

.SUBCKT analogue_interface \$11.IDACIREF \$12.CSOUT1 \$12.CSOUT2 \$12.CSOUT3
+ \$12.CSOUT4 \$12.PBIAS \$12.PCSVDD \$13.DIN \$13.DOUT \$13.PDIGVDD \$14.LIN
+ \$14.LOUT \$14.PLAVDD \$14.PLDVDD \$15.IOADISABLE \$15.IOAIREF \$15.IOAM
+ \$15.IOAP \$15.OOA \$15.POAVDD \$16.SH_EN \$16.SH_IN \$16.SH_OUT \$16.VDD
+ \$17.INN \$17.INP \$17.OUT \$17.PBIAS \$17.VCCA \$4.LIN \$4.LOUT \$4.PLAVDD
+ \$4.PLDVDD \$5.LIN \$5.LOUT \$5.PLAVDD \$5.PLDVDD \$6.LIN \$6.LOUT \$6.PLAVDD
+ \$6.PLDVDD \$7.LIN \$7.LOUT \$7.PLAVDD \$7.PLDVDD \$8.IDACIREF \$9.IDACIREF
+ VAPWR VGND VPWR analog_1 analog_2 dac_out[0] dac_out[10] dac_out[11]
+ dac_out[12] dac_out[13] dac_out[14] dac_out[15] dac_out[1] dac_out[2]
+ dac_out[3] dac_out[4] dac_out[5] dac_out[6] dac_out[7] dac_out[8] dac_out[9]
C$1 VGND \$I124 cap_cmomi w=50.48u l=3.48u A=0p P=0u m=1
R$2 \$I124 VGND VGND rhigh w=0.5u l=50u ps=0u b=0 m=1
R$3 \$I124 VAPWR VGND rhigh w=0.5u l=50u ps=0u b=0 m=1
M$4 VGND \$I150 \$I183 VGND sg13_hv_nmos L=2.4u W=0.6u AS=0.204p AD=0.114p
+ PS=1.88u PD=0.98u rfmode=0
M$5 \$I183 \$I149 \$I152 VGND sg13_hv_nmos L=0.6u W=0.6u AS=0.114p AD=0.204p
+ PS=0.98u PD=1.88u rfmode=0
M$6 VGND \$15.IOADISABLE \$I157 VGND sg13_hv_nmos L=0.6u W=0.6u AS=0.114p
+ AD=0.204p PS=0.98u PD=1.88u rfmode=0
M$7 VGND \$15.IOAIREF \$I171 VGND sg13_hv_nmos L=2.4u W=0.6u AS=0.204p
+ AD=0.204p PS=1.88u PD=1.88u rfmode=0
M$8 VGND \$15.IOAIREF \$15.IOAIREF VGND sg13_hv_nmos L=2.4u W=0.6u AS=0.204p
+ AD=0.204p PS=1.88u PD=1.88u rfmode=0
M$9 VGND \$15.IOAIREF VGND VGND sg13_hv_nmos L=2.4u W=1.2u AS=0.408p AD=0.408p
+ PS=3.76u PD=3.76u rfmode=0
M$10 VGND \$15.IOAIREF \$I172 VGND sg13_hv_nmos L=2.4u W=0.6u AS=0.204p
+ AD=0.204p PS=1.88u PD=1.88u rfmode=0
M$12 VGND \$I150 VGND VGND sg13_hv_nmos L=2.4u W=2.4u AS=0.546p AD=0.726p
+ PS=4.82u PD=6.62u rfmode=0
M$13 VGND \$15.IOADISABLE \$I162 VGND sg13_hv_nmos L=0.6u W=0.6u AS=0.114p
+ AD=0.204p PS=0.98u PD=1.88u rfmode=0
M$14 \$I159 \$I149 \$I154 VGND sg13_hv_nmos L=0.6u W=4.8u AS=1.272p AD=1.272p
+ PS=11.44u PD=11.44u rfmode=0
M$15 \$I154 \$I159 VGND VGND sg13_hv_nmos L=2.4u W=4.8u AS=1.272p AD=1.272p
+ PS=11.44u PD=11.44u rfmode=0
M$16 \$I157 \$I149 \$I155 VGND sg13_hv_nmos L=0.6u W=4.8u AS=1.272p AD=1.272p
+ PS=11.44u PD=11.44u rfmode=0
M$17 \$I155 \$I159 VGND VGND sg13_hv_nmos L=2.4u W=4.8u AS=1.272p AD=1.272p
+ PS=11.44u PD=11.44u rfmode=0
M$22 \$I164 \$I149 \$I151 VGND sg13_hv_nmos L=0.6u W=4.8u AS=1.272p AD=1.272p
+ PS=11.44u PD=11.44u rfmode=0
M$23 \$I151 \$I150 VGND VGND sg13_hv_nmos L=2.4u W=4.8u AS=1.272p AD=1.272p
+ PS=11.44u PD=11.44u rfmode=0
M$28 VGND \$I149 VGND VGND sg13_hv_nmos L=0.6u W=1.2u AS=0.408p AD=0.228p
+ PS=3.76u PD=1.96u rfmode=0
M$33 \$I153 \$15.IOADISABLE VGND VGND sg13_hv_nmos L=0.6u W=0.6u AS=0.204p
+ AD=0.114p PS=1.88u PD=0.98u rfmode=0
M$43 \$15.IOAIREF \$15.IOADISABLE VGND VGND sg13_hv_nmos L=0.6u W=0.6u
+ AS=0.204p AD=0.114p PS=1.88u PD=0.98u rfmode=0
M$49 VGND \$I150 \$I182 VGND sg13_hv_nmos L=2.4u W=0.6u AS=0.204p AD=0.114p
+ PS=1.88u PD=0.98u rfmode=0
M$50 \$I182 \$I149 \$I150 VGND sg13_hv_nmos L=0.6u W=0.6u AS=0.114p AD=0.204p
+ PS=0.98u PD=1.88u rfmode=0
M$71 \$15.POAVDD \$I172 \$I168 \$15.POAVDD sg13_hv_pmos L=1.2u W=9.6u AS=2.544p
+ AD=2.544p PS=18.64u PD=18.64u rfmode=0
M$72 \$I168 \$I171 \$I159 \$15.POAVDD sg13_hv_pmos L=0.6u W=9.6u AS=2.544p
+ AD=2.544p PS=18.64u PD=18.64u rfmode=0
M$79 \$15.POAVDD \$I172 \$15.POAVDD \$15.POAVDD sg13_hv_pmos L=1.2u W=7.2u
+ AS=2.088p AD=1.728p PS=15.48u PD=12.48u rfmode=0
M$80 \$15.POAVDD \$I171 \$15.POAVDD \$15.POAVDD sg13_hv_pmos L=0.6u W=7.2u
+ AS=1.728p AD=2.088p PS=12.48u PD=15.48u rfmode=0
M$81 \$15.POAVDD \$I172 \$I178 \$15.POAVDD sg13_hv_pmos L=1.2u W=1.2u AS=0.408p
+ AD=0.228p PS=3.08u PD=1.58u rfmode=0
M$82 \$I178 \$I171 \$I149 \$15.POAVDD sg13_hv_pmos L=0.6u W=1.2u AS=0.228p
+ AD=0.408p PS=1.58u PD=3.08u rfmode=0
M$83 \$15.POAVDD \$I172 \$I170 \$15.POAVDD sg13_hv_pmos L=1.2u W=9.6u AS=2.544p
+ AD=2.544p PS=18.64u PD=18.64u rfmode=0
M$84 \$I170 \$I171 \$I160 \$15.POAVDD sg13_hv_pmos L=0.6u W=9.6u AS=2.544p
+ AD=2.544p PS=18.64u PD=18.64u rfmode=0
M$97 \$I153 \$I171 \$I181 \$15.POAVDD sg13_hv_pmos L=0.6u W=1.2u AS=0.408p
+ AD=0.228p PS=3.08u PD=1.58u rfmode=0
M$98 \$I181 \$I172 \$15.POAVDD \$15.POAVDD sg13_hv_pmos L=1.2u W=1.2u AS=0.228p
+ AD=0.408p PS=1.58u PD=3.08u rfmode=0
M$105 \$I172 \$I171 \$I180 \$15.POAVDD sg13_hv_pmos L=0.6u W=1.2u AS=0.408p
+ AD=0.228p PS=3.08u PD=1.58u rfmode=0
M$106 \$I180 \$I172 \$15.POAVDD \$15.POAVDD sg13_hv_pmos L=1.2u W=1.2u
+ AS=0.228p AD=0.408p PS=1.58u PD=3.08u rfmode=0
M$113 \$I150 \$I171 \$I179 \$15.POAVDD sg13_hv_pmos L=0.6u W=1.2u AS=0.408p
+ AD=0.228p PS=3.08u PD=1.58u rfmode=0
M$114 \$I179 \$I172 \$15.POAVDD \$15.POAVDD sg13_hv_pmos L=1.2u W=1.2u
+ AS=0.228p AD=0.408p PS=1.58u PD=3.08u rfmode=0
M$123 \$I162 \$15.IOADISABLE \$15.POAVDD \$15.POAVDD sg13_hv_pmos L=0.6u W=1.2u
+ AS=0.408p AD=0.228p PS=3.08u PD=1.58u rfmode=0
M$124 \$15.POAVDD \$I162 \$I171 \$15.POAVDD sg13_hv_pmos L=0.6u W=1.2u
+ AS=0.228p AD=0.408p PS=1.58u PD=3.08u rfmode=0
M$125 \$I152 \$I162 \$15.POAVDD \$15.POAVDD sg13_hv_pmos L=0.6u W=1.2u
+ AS=0.408p AD=0.228p PS=3.08u PD=1.58u rfmode=0
M$126 \$15.POAVDD \$I162 \$I160 \$15.POAVDD sg13_hv_pmos L=0.6u W=1.2u
+ AS=0.228p AD=0.408p PS=1.58u PD=3.08u rfmode=0
M$127 \$17.VCCA \$I132 \$17.OUT \$17.VCCA sg13_hv_pmos L=0.45u W=1.2u AS=0.408p
+ AD=0.408p PS=3.76u PD=3.76u rfmode=0
M$129 \$17.VCCA \$I130 \$I132 \$17.VCCA sg13_hv_pmos L=0.45u W=0.6u AS=0.204p
+ AD=0.204p PS=1.88u PD=1.88u rfmode=0
M$130 \$I132 \$I130 VGND VGND sg13_hv_nmos L=0.45u W=0.3u AS=0.102p AD=0.102p
+ PS=1.28u PD=1.28u rfmode=0
M$131 \$17.OUT \$I132 VGND VGND sg13_hv_nmos L=0.45u W=0.6u AS=0.204p AD=0.204p
+ PS=2.56u PD=2.56u rfmode=0
M$133 VGND VGND VGND VGND sg13_hv_nmos L=0.45u W=79.2u AS=26.928p AD=26.928p
+ PS=192.4u PD=192.4u rfmode=0
M$135 \$I130 \$I133 VGND VGND sg13_hv_nmos L=0.45u W=2.4u AS=0.816p AD=0.816p
+ PS=5.48u PD=5.48u rfmode=0
M$136 \$17.VCCA \$17.PBIAS \$I138 \$17.VCCA sg13_hv_pmos L=1u W=0.8u AS=0.272p
+ AD=0.272p PS=2.28u PD=2.28u rfmode=0
M$137 \$17.VCCA \$17.VCCA \$17.VCCA \$17.VCCA sg13_hv_pmos L=1u W=1.6u
+ AS=0.544p AD=0.544p PS=4.56u PD=4.56u rfmode=0
M$138 \$17.VCCA \$17.PBIAS \$I130 \$17.VCCA sg13_hv_pmos L=1u W=0.8u AS=0.272p
+ AD=0.272p PS=2.28u PD=2.28u rfmode=0
M$140 \$17.VCCA \$17.VCCA \$17.VCCA \$17.VCCA sg13_hv_pmos L=0.45u W=40u
+ AS=13.6p AD=13.6p PS=88.16u PD=88.16u rfmode=0
M$148 \$I134 \$17.INN \$I138 \$17.VCCA sg13_hv_pmos L=0.45u W=10u AS=3.4p
+ AD=3.4p PS=21.36u PD=21.36u rfmode=0
M$149 \$I133 \$17.INP \$I138 \$17.VCCA sg13_hv_pmos L=0.45u W=10u AS=3.4p
+ AD=3.4p PS=21.36u PD=21.36u rfmode=0
M$156 VGND VGND VGND VGND sg13_hv_nmos L=1u W=0.8u AS=0.272p AD=0.272p PS=2.96u
+ PD=2.96u rfmode=0
M$157 \$I133 \$I134 VGND VGND sg13_hv_nmos L=1u W=0.4u AS=0.136p AD=0.136p
+ PS=1.48u PD=1.48u rfmode=0
M$159 \$I134 \$I134 VGND VGND sg13_hv_nmos L=1u W=0.4u AS=0.136p AD=0.136p
+ PS=1.48u PD=1.48u rfmode=0
C$160 \$16.SH_OUT VGND cap_cmomi w=54.93u l=29.52u A=0p P=0u m=1
M$161 VGND VGND VGND VGND sg13_hv_nmos L=0.6u W=86.4u AS=29.376p AD=29.376p
+ PS=221.76u PD=221.76u rfmode=0
M$162 \$I156 \$I156 VGND VGND sg13_hv_nmos L=0.6u W=1.2u AS=0.408p AD=0.408p
+ PS=3.08u PD=3.08u rfmode=0
M$164 \$I153 \$I153 \$I156 VGND sg13_hv_nmos L=0.6u W=1.2u AS=0.408p AD=0.408p
+ PS=3.08u PD=3.08u rfmode=0
M$165 \$15.OOA \$I157 VGND VGND sg13_hv_nmos L=0.6u W=48u AS=16.32p AD=16.32p
+ PS=123.2u PD=123.2u rfmode=0
M$221 \$I157 \$I153 \$I160 VGND sg13_hv_nmos L=0.6u W=4.8u AS=1.632p AD=1.632p
+ PS=12.32u PD=12.32u rfmode=0
M$225 VGND \$I149 VGND VGND sg13_hv_nmos L=10u W=0.8u AS=0.272p AD=0.272p
+ PS=2.96u PD=2.96u rfmode=0
M$226 \$I147 \$I149 VGND VGND sg13_hv_nmos L=10u W=0.4u AS=0.136p AD=0.136p
+ PS=1.48u PD=1.48u rfmode=0
M$228 \$I149 \$I149 \$I166 VGND sg13_hv_nmos L=10u W=0.4u AS=0.136p AD=0.136p
+ PS=1.48u PD=1.48u rfmode=0
M$229 \$I166 \$I149 \$I165 VGND sg13_hv_nmos L=10u W=0.4u AS=0.136p AD=0.136p
+ PS=1.48u PD=1.48u rfmode=0
M$230 \$I165 \$I149 \$I161 VGND sg13_hv_nmos L=10u W=0.4u AS=0.136p AD=0.136p
+ PS=1.48u PD=1.48u rfmode=0
M$231 \$I161 \$I149 \$I147 VGND sg13_hv_nmos L=10u W=0.4u AS=0.136p AD=0.136p
+ PS=1.48u PD=1.48u rfmode=0
M$232 \$I174 \$I171 \$I171 \$15.POAVDD sg13_hv_pmos L=10u W=1u AS=0.34p
+ AD=0.34p PS=2.68u PD=2.68u rfmode=0
M$233 \$15.POAVDD \$I171 \$15.POAVDD \$15.POAVDD sg13_hv_pmos L=10u W=2u
+ AS=0.68p AD=0.68p PS=5.36u PD=5.36u rfmode=0
M$234 \$15.POAVDD \$I171 \$I176 \$15.POAVDD sg13_hv_pmos L=10u W=1u AS=0.34p
+ AD=0.34p PS=2.68u PD=2.68u rfmode=0
M$235 \$I176 \$I171 \$I175 \$15.POAVDD sg13_hv_pmos L=10u W=1u AS=0.34p
+ AD=0.34p PS=2.68u PD=2.68u rfmode=0
M$237 \$I175 \$I171 \$I174 \$15.POAVDD sg13_hv_pmos L=10u W=1u AS=0.34p
+ AD=0.34p PS=2.68u PD=2.68u rfmode=0
M$246 \$15.OOA \$I160 \$15.POAVDD \$15.POAVDD sg13_hv_pmos L=0.4u W=96u
+ AS=32.64p AD=32.64p PS=219.2u PD=219.2u rfmode=0
M$247 \$15.POAVDD \$15.POAVDD \$15.POAVDD \$15.POAVDD sg13_hv_pmos L=0.4u
+ W=43.2u AS=14.688p AD=14.688p PS=98.64u PD=98.64u rfmode=0
M$290 \$I177 \$I152 \$I152 \$15.POAVDD sg13_hv_pmos L=0.4u W=2.4u AS=0.816p
+ AD=0.816p PS=5.48u PD=5.48u rfmode=0
M$291 \$I157 \$I152 \$I160 \$15.POAVDD sg13_hv_pmos L=0.4u W=9.6u AS=3.264p
+ AD=3.264p PS=21.92u PD=21.92u rfmode=0
M$308 \$15.POAVDD \$I177 \$I177 \$15.POAVDD sg13_hv_pmos L=0.4u W=2.4u
+ AS=0.816p AD=0.816p PS=5.48u PD=5.48u rfmode=0
M$314 \$I164 \$15.IOAP \$I170 VGND sg13_hv_nmos L=0.45u W=4.8u AS=1.632p
+ AD=1.632p PS=10.96u PD=10.96u rfmode=0
M$315 \$I164 \$15.IOAM \$I168 VGND sg13_hv_nmos L=0.45u W=4.8u AS=1.632p
+ AD=1.632p PS=10.96u PD=10.96u rfmode=0
M$318 \$I189 \$I190 \$4.PLDVDD \$4.PLDVDD sg13_lv_pmos L=0.13u W=0.3u AS=0.102p
+ AD=0.102p PS=1.28u PD=1.28u rfmode=0
M$319 \$I190 \$4.LIN \$4.PLDVDD \$4.PLDVDD sg13_lv_pmos L=0.13u W=0.3u
+ AS=0.102p AD=0.102p PS=1.28u PD=1.28u rfmode=0
M$320 \$I197 \$I198 \$5.PLDVDD \$5.PLDVDD sg13_lv_pmos L=0.13u W=0.3u AS=0.102p
+ AD=0.102p PS=1.28u PD=1.28u rfmode=0
M$321 \$I198 \$5.LIN \$5.PLDVDD \$5.PLDVDD sg13_lv_pmos L=0.13u W=0.3u
+ AS=0.102p AD=0.102p PS=1.28u PD=1.28u rfmode=0
M$322 \$I205 \$I206 \$6.PLDVDD \$6.PLDVDD sg13_lv_pmos L=0.13u W=0.3u AS=0.102p
+ AD=0.102p PS=1.28u PD=1.28u rfmode=0
M$323 \$I206 \$6.LIN \$6.PLDVDD \$6.PLDVDD sg13_lv_pmos L=0.13u W=0.3u
+ AS=0.102p AD=0.102p PS=1.28u PD=1.28u rfmode=0
M$324 \$I213 \$I214 \$7.PLDVDD \$7.PLDVDD sg13_lv_pmos L=0.13u W=0.3u AS=0.102p
+ AD=0.102p PS=1.28u PD=1.28u rfmode=0
M$325 \$I214 \$7.LIN \$7.PLDVDD \$7.PLDVDD sg13_lv_pmos L=0.13u W=0.3u
+ AS=0.102p AD=0.102p PS=1.28u PD=1.28u rfmode=0
M$326 \$I221 \$I222 \$14.PLDVDD \$14.PLDVDD sg13_lv_pmos L=0.13u W=0.3u
+ AS=0.102p AD=0.102p PS=1.28u PD=1.28u rfmode=0
M$327 \$I222 \$14.LIN \$14.PLDVDD \$14.PLDVDD sg13_lv_pmos L=0.13u W=0.3u
+ AS=0.102p AD=0.102p PS=1.28u PD=1.28u rfmode=0
M$328 VGND \$I190 \$I189 VGND sg13_lv_nmos L=0.13u W=0.15u AS=0.1005p
+ AD=0.1005p PS=1.34u PD=1.34u rfmode=0
M$329 VGND \$4.LIN \$I190 VGND sg13_lv_nmos L=0.13u W=0.15u AS=0.1005p
+ AD=0.1005p PS=1.34u PD=1.34u rfmode=0
M$330 VGND \$I198 \$I197 VGND sg13_lv_nmos L=0.13u W=0.15u AS=0.1005p
+ AD=0.1005p PS=1.34u PD=1.34u rfmode=0
M$331 VGND \$5.LIN \$I198 VGND sg13_lv_nmos L=0.13u W=0.15u AS=0.1005p
+ AD=0.1005p PS=1.34u PD=1.34u rfmode=0
M$332 VGND \$I206 \$I205 VGND sg13_lv_nmos L=0.13u W=0.15u AS=0.1005p
+ AD=0.1005p PS=1.34u PD=1.34u rfmode=0
M$333 VGND \$6.LIN \$I206 VGND sg13_lv_nmos L=0.13u W=0.15u AS=0.1005p
+ AD=0.1005p PS=1.34u PD=1.34u rfmode=0
M$334 VGND \$I214 \$I213 VGND sg13_lv_nmos L=0.13u W=0.15u AS=0.1005p
+ AD=0.1005p PS=1.34u PD=1.34u rfmode=0
M$335 VGND \$7.LIN \$I214 VGND sg13_lv_nmos L=0.13u W=0.15u AS=0.1005p
+ AD=0.1005p PS=1.34u PD=1.34u rfmode=0
M$336 VGND \$I222 \$I221 VGND sg13_lv_nmos L=0.13u W=0.15u AS=0.1005p
+ AD=0.1005p PS=1.34u PD=1.34u rfmode=0
M$337 VGND \$14.LIN \$I222 VGND sg13_lv_nmos L=0.13u W=0.15u AS=0.1005p
+ AD=0.1005p PS=1.34u PD=1.34u rfmode=0
M$338 VGND \$I188 \$4.LOUT VGND sg13_hv_nmos L=0.45u W=1.2u AS=0.408p AD=0.408p
+ PS=5.12u PD=5.12u rfmode=0
M$342 VGND \$I196 \$5.LOUT VGND sg13_hv_nmos L=0.45u W=1.2u AS=0.408p AD=0.408p
+ PS=5.12u PD=5.12u rfmode=0
M$346 VGND \$I204 \$6.LOUT VGND sg13_hv_nmos L=0.45u W=1.2u AS=0.408p AD=0.408p
+ PS=5.12u PD=5.12u rfmode=0
M$350 VGND \$I212 \$7.LOUT VGND sg13_hv_nmos L=0.45u W=1.2u AS=0.408p AD=0.408p
+ PS=5.12u PD=5.12u rfmode=0
M$354 VGND \$I220 \$14.LOUT VGND sg13_hv_nmos L=0.45u W=1.2u AS=0.408p
+ AD=0.408p PS=5.12u PD=5.12u rfmode=0
M$358 \$4.LOUT \$I188 \$4.PLAVDD \$4.PLAVDD sg13_hv_pmos L=0.45u W=2.4u
+ AS=0.816p AD=0.816p PS=7.52u PD=7.52u rfmode=0
M$362 \$5.LOUT \$I196 \$5.PLAVDD \$5.PLAVDD sg13_hv_pmos L=0.45u W=2.4u
+ AS=0.816p AD=0.816p PS=7.52u PD=7.52u rfmode=0
M$366 \$6.LOUT \$I204 \$6.PLAVDD \$6.PLAVDD sg13_hv_pmos L=0.45u W=2.4u
+ AS=0.816p AD=0.816p PS=7.52u PD=7.52u rfmode=0
M$370 \$7.LOUT \$I212 \$7.PLAVDD \$7.PLAVDD sg13_hv_pmos L=0.45u W=2.4u
+ AS=0.816p AD=0.816p PS=7.52u PD=7.52u rfmode=0
M$374 \$14.LOUT \$I220 \$14.PLAVDD \$14.PLAVDD sg13_hv_pmos L=0.45u W=2.4u
+ AS=0.816p AD=0.816p PS=7.52u PD=7.52u rfmode=0
M$378 \$I188 \$I191 \$4.PLAVDD \$4.PLAVDD sg13_hv_pmos L=0.45u W=0.3u AS=0.102p
+ AD=0.102p PS=1.28u PD=1.28u rfmode=0
M$379 \$I191 \$I188 \$4.PLAVDD \$4.PLAVDD sg13_hv_pmos L=0.45u W=0.3u AS=0.102p
+ AD=0.102p PS=1.28u PD=1.28u rfmode=0
M$380 \$I196 \$I199 \$5.PLAVDD \$5.PLAVDD sg13_hv_pmos L=0.45u W=0.3u AS=0.102p
+ AD=0.102p PS=1.28u PD=1.28u rfmode=0
M$381 \$I199 \$I196 \$5.PLAVDD \$5.PLAVDD sg13_hv_pmos L=0.45u W=0.3u AS=0.102p
+ AD=0.102p PS=1.28u PD=1.28u rfmode=0
M$382 \$I204 \$I207 \$6.PLAVDD \$6.PLAVDD sg13_hv_pmos L=0.45u W=0.3u AS=0.102p
+ AD=0.102p PS=1.28u PD=1.28u rfmode=0
M$383 \$I207 \$I204 \$6.PLAVDD \$6.PLAVDD sg13_hv_pmos L=0.45u W=0.3u AS=0.102p
+ AD=0.102p PS=1.28u PD=1.28u rfmode=0
M$384 \$I212 \$I215 \$7.PLAVDD \$7.PLAVDD sg13_hv_pmos L=0.45u W=0.3u AS=0.102p
+ AD=0.102p PS=1.28u PD=1.28u rfmode=0
M$385 \$I215 \$I212 \$7.PLAVDD \$7.PLAVDD sg13_hv_pmos L=0.45u W=0.3u AS=0.102p
+ AD=0.102p PS=1.28u PD=1.28u rfmode=0
M$386 \$I220 \$I223 \$14.PLAVDD \$14.PLAVDD sg13_hv_pmos L=0.45u W=0.3u
+ AS=0.102p AD=0.102p PS=1.28u PD=1.28u rfmode=0
M$387 \$I223 \$I220 \$14.PLAVDD \$14.PLAVDD sg13_hv_pmos L=0.45u W=0.3u
+ AS=0.102p AD=0.102p PS=1.28u PD=1.28u rfmode=0
M$388 VGND \$I190 \$I191 VGND sg13_hv_nmos L=0.45u W=1u AS=0.34p AD=0.34p
+ PS=2.68u PD=2.68u rfmode=0
M$389 VGND \$I189 \$I188 VGND sg13_hv_nmos L=0.45u W=1u AS=0.34p AD=0.34p
+ PS=2.68u PD=2.68u rfmode=0
M$390 VGND \$I198 \$I199 VGND sg13_hv_nmos L=0.45u W=1u AS=0.34p AD=0.34p
+ PS=2.68u PD=2.68u rfmode=0
M$391 VGND \$I197 \$I196 VGND sg13_hv_nmos L=0.45u W=1u AS=0.34p AD=0.34p
+ PS=2.68u PD=2.68u rfmode=0
M$392 VGND \$I206 \$I207 VGND sg13_hv_nmos L=0.45u W=1u AS=0.34p AD=0.34p
+ PS=2.68u PD=2.68u rfmode=0
M$393 VGND \$I205 \$I204 VGND sg13_hv_nmos L=0.45u W=1u AS=0.34p AD=0.34p
+ PS=2.68u PD=2.68u rfmode=0
M$394 VGND \$I214 \$I215 VGND sg13_hv_nmos L=0.45u W=1u AS=0.34p AD=0.34p
+ PS=2.68u PD=2.68u rfmode=0
M$395 VGND \$I213 \$I212 VGND sg13_hv_nmos L=0.45u W=1u AS=0.34p AD=0.34p
+ PS=2.68u PD=2.68u rfmode=0
M$396 VGND \$I222 \$I223 VGND sg13_hv_nmos L=0.45u W=1u AS=0.34p AD=0.34p
+ PS=2.68u PD=2.68u rfmode=0
M$397 VGND \$I221 \$I220 VGND sg13_hv_nmos L=0.45u W=1u AS=0.34p AD=0.34p
+ PS=2.68u PD=2.68u rfmode=0
M$398 \$13.PDIGVDD \$I227 \$13.DOUT \$13.PDIGVDD sg13_hv_pmos L=0.45u W=0.6u
+ AS=0.204p AD=0.204p PS=1.88u PD=1.88u rfmode=0
M$399 \$13.PDIGVDD \$13.DIN \$I227 \$13.PDIGVDD sg13_hv_pmos L=0.45u W=0.6u
+ AS=0.204p AD=0.204p PS=1.88u PD=1.88u rfmode=0
M$400 \$I227 \$13.DIN VGND VGND sg13_hv_nmos L=0.45u W=0.3u AS=0.102p AD=0.102p
+ PS=1.28u PD=1.28u rfmode=0
M$401 \$13.DOUT \$I227 VGND VGND sg13_hv_nmos L=0.45u W=0.3u AS=0.102p
+ AD=0.102p PS=1.28u PD=1.28u rfmode=0
M$402 VGND VGND VGND VGND sg13_hv_nmos L=2u W=60u AS=20.4p AD=20.4p PS=130.88u
+ PD=130.88u rfmode=0
M$404 \$12.PBIAS \$I229 \$I228 VGND sg13_hv_nmos L=2u W=10u AS=3.4p AD=3.4p
+ PS=20.68u PD=20.68u rfmode=0
M$411 \$12.PBIAS \$I236 VGND \$12.PCSVDD sg13_hv_pmos L=1u W=0.4u AS=0.136p
+ AD=0.136p PS=1.48u PD=1.48u rfmode=0
M$412 \$12.PCSVDD \$12.PBIAS \$12.CSOUT2 \$12.PCSVDD sg13_hv_pmos L=1u W=0.4u
+ AS=0.136p AD=0.136p PS=1.48u PD=1.48u rfmode=0
M$413 \$12.PCSVDD \$12.PBIAS \$12.CSOUT3 \$12.PCSVDD sg13_hv_pmos L=1u W=0.4u
+ AS=0.136p AD=0.136p PS=1.48u PD=1.48u rfmode=0
M$414 \$12.PCSVDD \$12.PCSVDD \$12.PCSVDD \$12.PCSVDD sg13_hv_pmos L=1u W=8.8u
+ AS=2.992p AD=2.992p PS=32.56u PD=32.56u rfmode=0
M$415 \$12.PCSVDD \$12.PBIAS \$I236 \$12.PCSVDD sg13_hv_pmos L=1u W=0.4u
+ AS=0.136p AD=0.136p PS=1.48u PD=1.48u rfmode=0
M$424 \$12.PCSVDD \$12.PBIAS \$I229 \$12.PCSVDD sg13_hv_pmos L=1u W=0.4u
+ AS=0.136p AD=0.136p PS=1.48u PD=1.48u rfmode=0
M$425 \$12.PCSVDD \$12.PBIAS \$12.PBIAS \$12.PCSVDD sg13_hv_pmos L=1u W=0.4u
+ AS=0.136p AD=0.136p PS=1.48u PD=1.48u rfmode=0
M$437 \$12.PCSVDD \$12.PBIAS \$12.CSOUT4 \$12.PCSVDD sg13_hv_pmos L=1u W=0.4u
+ AS=0.136p AD=0.136p PS=1.48u PD=1.48u rfmode=0
M$439 \$12.PCSVDD \$12.PBIAS \$12.CSOUT1 \$12.PCSVDD sg13_hv_pmos L=1u W=0.4u
+ AS=0.136p AD=0.136p PS=1.48u PD=1.48u rfmode=0
M$443 \$I229 \$I229 VGND VGND sg13_hv_nmos L=2u W=2u AS=0.68p AD=0.68p PS=4.68u
+ PD=4.68u rfmode=0
R$450 \$I228 VGND VGND rhigh w=0.5u l=31.135u ps=0.18u b=21 m=1
M$451 \$I232 VGND VGND \$I232 sg13_hv_pmos L=3u W=0.3u AS=0.102p AD=0.102p
+ PS=1.28u PD=1.28u rfmode=0
M$452 \$I235 \$I234 \$I234 \$I235 sg13_hv_pmos L=3u W=0.3u AS=0.102p AD=0.102p
+ PS=1.28u PD=1.28u rfmode=0
M$453 \$I233 \$I232 \$I232 \$I233 sg13_hv_pmos L=3u W=0.3u AS=0.102p AD=0.102p
+ PS=1.28u PD=1.28u rfmode=0
M$454 \$I236 \$I235 \$I235 \$I236 sg13_hv_pmos L=3u W=0.3u AS=0.102p AD=0.102p
+ PS=1.28u PD=1.28u rfmode=0
M$455 \$12.PCSVDD \$12.PCSVDD \$12.PCSVDD \$12.PCSVDD sg13_hv_pmos L=3u W=0.6u
+ AS=0.204p AD=0.204p PS=2.56u PD=2.56u rfmode=0
M$456 \$I234 \$I233 \$I233 \$I234 sg13_hv_pmos L=3u W=0.3u AS=0.102p AD=0.102p
+ PS=1.28u PD=1.28u rfmode=0
M$458 VGND \$I307 \$I335 VGND sg13_hv_nmos L=2.4u W=0.6u AS=0.204p AD=0.114p
+ PS=1.88u PD=0.98u rfmode=0
M$459 \$I335 \$I306 \$I309 VGND sg13_hv_nmos L=0.6u W=0.6u AS=0.114p AD=0.204p
+ PS=0.98u PD=1.88u rfmode=0
M$460 VGND VGND \$I314 VGND sg13_hv_nmos L=0.6u W=0.6u AS=0.114p AD=0.204p
+ PS=0.98u PD=1.88u rfmode=0
M$461 VGND \$8.IDACIREF \$I324 VGND sg13_hv_nmos L=2.4u W=0.6u AS=0.204p
+ AD=0.204p PS=1.88u PD=1.88u rfmode=0
M$462 VGND \$8.IDACIREF \$8.IDACIREF VGND sg13_hv_nmos L=2.4u W=0.6u AS=0.204p
+ AD=0.204p PS=1.88u PD=1.88u rfmode=0
M$463 VGND \$8.IDACIREF VGND VGND sg13_hv_nmos L=2.4u W=1.2u AS=0.408p
+ AD=0.408p PS=3.76u PD=3.76u rfmode=0
M$464 VGND \$8.IDACIREF \$I325 VGND sg13_hv_nmos L=2.4u W=0.6u AS=0.204p
+ AD=0.204p PS=1.88u PD=1.88u rfmode=0
M$466 VGND \$I307 VGND VGND sg13_hv_nmos L=2.4u W=2.4u AS=0.546p AD=0.726p
+ PS=4.82u PD=6.62u rfmode=0
M$467 VGND VGND \$I318 VGND sg13_hv_nmos L=0.6u W=0.6u AS=0.114p AD=0.204p
+ PS=0.98u PD=1.88u rfmode=0
M$468 \$I315 \$I306 \$I311 VGND sg13_hv_nmos L=0.6u W=4.8u AS=1.272p AD=1.272p
+ PS=11.44u PD=11.44u rfmode=0
M$469 \$I311 \$I315 VGND VGND sg13_hv_nmos L=2.4u W=4.8u AS=1.272p AD=1.272p
+ PS=11.44u PD=11.44u rfmode=0
M$470 \$I314 \$I306 \$I312 VGND sg13_hv_nmos L=0.6u W=4.8u AS=1.272p AD=1.272p
+ PS=11.44u PD=11.44u rfmode=0
M$471 \$I312 \$I315 VGND VGND sg13_hv_nmos L=2.4u W=4.8u AS=1.272p AD=1.272p
+ PS=11.44u PD=11.44u rfmode=0
M$476 \$I319 \$I306 \$I308 VGND sg13_hv_nmos L=0.6u W=4.8u AS=1.272p AD=1.272p
+ PS=11.44u PD=11.44u rfmode=0
M$477 \$I308 \$I307 VGND VGND sg13_hv_nmos L=2.4u W=4.8u AS=1.272p AD=1.272p
+ PS=11.44u PD=11.44u rfmode=0
M$482 VGND \$I306 VGND VGND sg13_hv_nmos L=0.6u W=1.2u AS=0.408p AD=0.228p
+ PS=3.76u PD=1.96u rfmode=0
M$487 \$I310 VGND VGND VGND sg13_hv_nmos L=0.6u W=0.6u AS=0.204p AD=0.114p
+ PS=1.88u PD=0.98u rfmode=0
M$497 \$8.IDACIREF VGND VGND VGND sg13_hv_nmos L=0.6u W=0.6u AS=0.204p
+ AD=0.114p PS=1.88u PD=0.98u rfmode=0
M$503 VGND \$I307 \$I334 VGND sg13_hv_nmos L=2.4u W=0.6u AS=0.204p AD=0.114p
+ PS=1.88u PD=0.98u rfmode=0
M$504 \$I334 \$I306 \$I307 VGND sg13_hv_nmos L=0.6u W=0.6u AS=0.114p AD=0.204p
+ PS=0.98u PD=1.88u rfmode=0
M$525 VAPWR \$I325 \$I322 VAPWR sg13_hv_pmos L=1.2u W=9.6u AS=2.544p AD=2.544p
+ PS=18.64u PD=18.64u rfmode=0
M$526 \$I322 \$I324 \$I315 VAPWR sg13_hv_pmos L=0.6u W=9.6u AS=2.544p AD=2.544p
+ PS=18.64u PD=18.64u rfmode=0
M$533 VAPWR \$I325 VAPWR VAPWR sg13_hv_pmos L=1.2u W=7.2u AS=2.088p AD=1.728p
+ PS=15.48u PD=12.48u rfmode=0
M$534 VAPWR \$I324 VAPWR VAPWR sg13_hv_pmos L=0.6u W=7.2u AS=1.728p AD=2.088p
+ PS=12.48u PD=15.48u rfmode=0
M$535 VAPWR \$I325 \$I333 VAPWR sg13_hv_pmos L=1.2u W=1.2u AS=0.408p AD=0.228p
+ PS=3.08u PD=1.58u rfmode=0
M$536 \$I333 \$I324 \$I306 VAPWR sg13_hv_pmos L=0.6u W=1.2u AS=0.228p AD=0.408p
+ PS=1.58u PD=3.08u rfmode=0
M$537 VAPWR \$I325 \$I323 VAPWR sg13_hv_pmos L=1.2u W=9.6u AS=2.544p AD=2.544p
+ PS=18.64u PD=18.64u rfmode=0
M$538 \$I323 \$I324 \$I316 VAPWR sg13_hv_pmos L=0.6u W=9.6u AS=2.544p AD=2.544p
+ PS=18.64u PD=18.64u rfmode=0
M$551 \$I310 \$I324 \$I330 VAPWR sg13_hv_pmos L=0.6u W=1.2u AS=0.408p AD=0.228p
+ PS=3.08u PD=1.58u rfmode=0
M$552 \$I330 \$I325 VAPWR VAPWR sg13_hv_pmos L=1.2u W=1.2u AS=0.228p AD=0.408p
+ PS=1.58u PD=3.08u rfmode=0
M$559 \$I325 \$I324 \$I331 VAPWR sg13_hv_pmos L=0.6u W=1.2u AS=0.408p AD=0.228p
+ PS=3.08u PD=1.58u rfmode=0
M$560 \$I331 \$I325 VAPWR VAPWR sg13_hv_pmos L=1.2u W=1.2u AS=0.228p AD=0.408p
+ PS=1.58u PD=3.08u rfmode=0
M$567 \$I307 \$I324 \$I332 VAPWR sg13_hv_pmos L=0.6u W=1.2u AS=0.408p AD=0.228p
+ PS=3.08u PD=1.58u rfmode=0
M$568 \$I332 \$I325 VAPWR VAPWR sg13_hv_pmos L=1.2u W=1.2u AS=0.228p AD=0.408p
+ PS=1.58u PD=3.08u rfmode=0
M$577 \$I318 VGND VAPWR VAPWR sg13_hv_pmos L=0.6u W=1.2u AS=0.408p AD=0.228p
+ PS=3.08u PD=1.58u rfmode=0
M$578 VAPWR \$I318 \$I324 VAPWR sg13_hv_pmos L=0.6u W=1.2u AS=0.228p AD=0.408p
+ PS=1.58u PD=3.08u rfmode=0
M$579 \$I309 \$I318 VAPWR VAPWR sg13_hv_pmos L=0.6u W=1.2u AS=0.408p AD=0.228p
+ PS=3.08u PD=1.58u rfmode=0
M$580 VAPWR \$I318 \$I316 VAPWR sg13_hv_pmos L=0.6u W=1.2u AS=0.228p AD=0.408p
+ PS=1.58u PD=3.08u rfmode=0
M$581 VGND \$I338 \$I366 VGND sg13_hv_nmos L=2.4u W=0.6u AS=0.204p AD=0.114p
+ PS=1.88u PD=0.98u rfmode=0
M$582 \$I366 \$I337 \$I340 VGND sg13_hv_nmos L=0.6u W=0.6u AS=0.114p AD=0.204p
+ PS=0.98u PD=1.88u rfmode=0
M$583 VGND \$I73 \$I345 VGND sg13_hv_nmos L=0.6u W=0.6u AS=0.114p AD=0.204p
+ PS=0.98u PD=1.88u rfmode=0
M$584 VGND \$9.IDACIREF \$I355 VGND sg13_hv_nmos L=2.4u W=0.6u AS=0.204p
+ AD=0.204p PS=1.88u PD=1.88u rfmode=0
M$585 VGND \$9.IDACIREF \$9.IDACIREF VGND sg13_hv_nmos L=2.4u W=0.6u AS=0.204p
+ AD=0.204p PS=1.88u PD=1.88u rfmode=0
M$586 VGND \$9.IDACIREF VGND VGND sg13_hv_nmos L=2.4u W=1.2u AS=0.408p
+ AD=0.408p PS=3.76u PD=3.76u rfmode=0
M$587 VGND \$9.IDACIREF \$I356 VGND sg13_hv_nmos L=2.4u W=0.6u AS=0.204p
+ AD=0.204p PS=1.88u PD=1.88u rfmode=0
M$589 VGND \$I338 VGND VGND sg13_hv_nmos L=2.4u W=2.4u AS=0.546p AD=0.726p
+ PS=4.82u PD=6.62u rfmode=0
M$590 VGND \$I73 \$I349 VGND sg13_hv_nmos L=0.6u W=0.6u AS=0.114p AD=0.204p
+ PS=0.98u PD=1.88u rfmode=0
M$591 \$I346 \$I337 \$I342 VGND sg13_hv_nmos L=0.6u W=4.8u AS=1.272p AD=1.272p
+ PS=11.44u PD=11.44u rfmode=0
M$592 \$I342 \$I346 VGND VGND sg13_hv_nmos L=2.4u W=4.8u AS=1.272p AD=1.272p
+ PS=11.44u PD=11.44u rfmode=0
M$593 \$I345 \$I337 \$I343 VGND sg13_hv_nmos L=0.6u W=4.8u AS=1.272p AD=1.272p
+ PS=11.44u PD=11.44u rfmode=0
M$594 \$I343 \$I346 VGND VGND sg13_hv_nmos L=2.4u W=4.8u AS=1.272p AD=1.272p
+ PS=11.44u PD=11.44u rfmode=0
M$599 \$I350 \$I337 \$I339 VGND sg13_hv_nmos L=0.6u W=4.8u AS=1.272p AD=1.272p
+ PS=11.44u PD=11.44u rfmode=0
M$600 \$I339 \$I338 VGND VGND sg13_hv_nmos L=2.4u W=4.8u AS=1.272p AD=1.272p
+ PS=11.44u PD=11.44u rfmode=0
M$605 VGND \$I337 VGND VGND sg13_hv_nmos L=0.6u W=1.2u AS=0.408p AD=0.228p
+ PS=3.76u PD=1.96u rfmode=0
M$610 \$I341 \$I73 VGND VGND sg13_hv_nmos L=0.6u W=0.6u AS=0.204p AD=0.114p
+ PS=1.88u PD=0.98u rfmode=0
M$620 \$9.IDACIREF \$I73 VGND VGND sg13_hv_nmos L=0.6u W=0.6u AS=0.204p
+ AD=0.114p PS=1.88u PD=0.98u rfmode=0
M$626 VGND \$I338 \$I365 VGND sg13_hv_nmos L=2.4u W=0.6u AS=0.204p AD=0.114p
+ PS=1.88u PD=0.98u rfmode=0
M$627 \$I365 \$I337 \$I338 VGND sg13_hv_nmos L=0.6u W=0.6u AS=0.114p AD=0.204p
+ PS=0.98u PD=1.88u rfmode=0
M$648 VAPWR \$I356 \$I353 VAPWR sg13_hv_pmos L=1.2u W=9.6u AS=2.544p AD=2.544p
+ PS=18.64u PD=18.64u rfmode=0
M$649 \$I353 \$I355 \$I346 VAPWR sg13_hv_pmos L=0.6u W=9.6u AS=2.544p AD=2.544p
+ PS=18.64u PD=18.64u rfmode=0
M$656 VAPWR \$I356 VAPWR VAPWR sg13_hv_pmos L=1.2u W=7.2u AS=2.088p AD=1.728p
+ PS=15.48u PD=12.48u rfmode=0
M$657 VAPWR \$I355 VAPWR VAPWR sg13_hv_pmos L=0.6u W=7.2u AS=1.728p AD=2.088p
+ PS=12.48u PD=15.48u rfmode=0
M$658 VAPWR \$I356 \$I364 VAPWR sg13_hv_pmos L=1.2u W=1.2u AS=0.408p AD=0.228p
+ PS=3.08u PD=1.58u rfmode=0
M$659 \$I364 \$I355 \$I337 VAPWR sg13_hv_pmos L=0.6u W=1.2u AS=0.228p AD=0.408p
+ PS=1.58u PD=3.08u rfmode=0
M$660 VAPWR \$I356 \$I354 VAPWR sg13_hv_pmos L=1.2u W=9.6u AS=2.544p AD=2.544p
+ PS=18.64u PD=18.64u rfmode=0
M$661 \$I354 \$I355 \$I347 VAPWR sg13_hv_pmos L=0.6u W=9.6u AS=2.544p AD=2.544p
+ PS=18.64u PD=18.64u rfmode=0
M$674 \$I341 \$I355 \$I361 VAPWR sg13_hv_pmos L=0.6u W=1.2u AS=0.408p AD=0.228p
+ PS=3.08u PD=1.58u rfmode=0
M$675 \$I361 \$I356 VAPWR VAPWR sg13_hv_pmos L=1.2u W=1.2u AS=0.228p AD=0.408p
+ PS=1.58u PD=3.08u rfmode=0
M$682 \$I356 \$I355 \$I362 VAPWR sg13_hv_pmos L=0.6u W=1.2u AS=0.408p AD=0.228p
+ PS=3.08u PD=1.58u rfmode=0
M$683 \$I362 \$I356 VAPWR VAPWR sg13_hv_pmos L=1.2u W=1.2u AS=0.228p AD=0.408p
+ PS=1.58u PD=3.08u rfmode=0
M$690 \$I338 \$I355 \$I363 VAPWR sg13_hv_pmos L=0.6u W=1.2u AS=0.408p AD=0.228p
+ PS=3.08u PD=1.58u rfmode=0
M$691 \$I363 \$I356 VAPWR VAPWR sg13_hv_pmos L=1.2u W=1.2u AS=0.228p AD=0.408p
+ PS=1.58u PD=3.08u rfmode=0
M$700 \$I349 \$I73 VAPWR VAPWR sg13_hv_pmos L=0.6u W=1.2u AS=0.408p AD=0.228p
+ PS=3.08u PD=1.58u rfmode=0
M$701 VAPWR \$I349 \$I355 VAPWR sg13_hv_pmos L=0.6u W=1.2u AS=0.228p AD=0.408p
+ PS=1.58u PD=3.08u rfmode=0
M$702 \$I340 \$I349 VAPWR VAPWR sg13_hv_pmos L=0.6u W=1.2u AS=0.408p AD=0.228p
+ PS=3.08u PD=1.58u rfmode=0
M$703 VAPWR \$I349 \$I347 VAPWR sg13_hv_pmos L=0.6u W=1.2u AS=0.228p AD=0.408p
+ PS=1.58u PD=3.08u rfmode=0
M$704 VGND \$I369 \$I397 VGND sg13_hv_nmos L=2.4u W=0.6u AS=0.204p AD=0.114p
+ PS=1.88u PD=0.98u rfmode=0
M$705 \$I397 \$I368 \$I371 VGND sg13_hv_nmos L=0.6u W=0.6u AS=0.114p AD=0.204p
+ PS=0.98u PD=1.88u rfmode=0
M$706 VGND VGND \$I376 VGND sg13_hv_nmos L=0.6u W=0.6u AS=0.114p AD=0.204p
+ PS=0.98u PD=1.88u rfmode=0
M$707 VGND \$11.IDACIREF \$I386 VGND sg13_hv_nmos L=2.4u W=0.6u AS=0.204p
+ AD=0.204p PS=1.88u PD=1.88u rfmode=0
M$708 VGND \$11.IDACIREF \$11.IDACIREF VGND sg13_hv_nmos L=2.4u W=0.6u
+ AS=0.204p AD=0.204p PS=1.88u PD=1.88u rfmode=0
M$709 VGND \$11.IDACIREF VGND VGND sg13_hv_nmos L=2.4u W=1.2u AS=0.408p
+ AD=0.408p PS=3.76u PD=3.76u rfmode=0
M$710 VGND \$11.IDACIREF \$I387 VGND sg13_hv_nmos L=2.4u W=0.6u AS=0.204p
+ AD=0.204p PS=1.88u PD=1.88u rfmode=0
M$712 VGND \$I369 VGND VGND sg13_hv_nmos L=2.4u W=2.4u AS=0.546p AD=0.726p
+ PS=4.82u PD=6.62u rfmode=0
M$713 VGND VGND \$I380 VGND sg13_hv_nmos L=0.6u W=0.6u AS=0.114p AD=0.204p
+ PS=0.98u PD=1.88u rfmode=0
M$714 \$I377 \$I368 \$I373 VGND sg13_hv_nmos L=0.6u W=4.8u AS=1.272p AD=1.272p
+ PS=11.44u PD=11.44u rfmode=0
M$715 \$I373 \$I377 VGND VGND sg13_hv_nmos L=2.4u W=4.8u AS=1.272p AD=1.272p
+ PS=11.44u PD=11.44u rfmode=0
M$716 \$I376 \$I368 \$I374 VGND sg13_hv_nmos L=0.6u W=4.8u AS=1.272p AD=1.272p
+ PS=11.44u PD=11.44u rfmode=0
M$717 \$I374 \$I377 VGND VGND sg13_hv_nmos L=2.4u W=4.8u AS=1.272p AD=1.272p
+ PS=11.44u PD=11.44u rfmode=0
M$722 \$I381 \$I368 \$I370 VGND sg13_hv_nmos L=0.6u W=4.8u AS=1.272p AD=1.272p
+ PS=11.44u PD=11.44u rfmode=0
M$723 \$I370 \$I369 VGND VGND sg13_hv_nmos L=2.4u W=4.8u AS=1.272p AD=1.272p
+ PS=11.44u PD=11.44u rfmode=0
M$728 VGND \$I368 VGND VGND sg13_hv_nmos L=0.6u W=1.2u AS=0.408p AD=0.228p
+ PS=3.76u PD=1.96u rfmode=0
M$733 \$I372 VGND VGND VGND sg13_hv_nmos L=0.6u W=0.6u AS=0.204p AD=0.114p
+ PS=1.88u PD=0.98u rfmode=0
M$743 \$11.IDACIREF VGND VGND VGND sg13_hv_nmos L=0.6u W=0.6u AS=0.204p
+ AD=0.114p PS=1.88u PD=0.98u rfmode=0
M$749 VGND \$I369 \$I396 VGND sg13_hv_nmos L=2.4u W=0.6u AS=0.204p AD=0.114p
+ PS=1.88u PD=0.98u rfmode=0
M$750 \$I396 \$I368 \$I369 VGND sg13_hv_nmos L=0.6u W=0.6u AS=0.114p AD=0.204p
+ PS=0.98u PD=1.88u rfmode=0
M$771 VAPWR \$I387 \$I384 VAPWR sg13_hv_pmos L=1.2u W=9.6u AS=2.544p AD=2.544p
+ PS=18.64u PD=18.64u rfmode=0
M$772 \$I384 \$I386 \$I377 VAPWR sg13_hv_pmos L=0.6u W=9.6u AS=2.544p AD=2.544p
+ PS=18.64u PD=18.64u rfmode=0
M$779 VAPWR \$I387 VAPWR VAPWR sg13_hv_pmos L=1.2u W=7.2u AS=2.088p AD=1.728p
+ PS=15.48u PD=12.48u rfmode=0
M$780 VAPWR \$I386 VAPWR VAPWR sg13_hv_pmos L=0.6u W=7.2u AS=1.728p AD=2.088p
+ PS=12.48u PD=15.48u rfmode=0
M$781 VAPWR \$I387 \$I395 VAPWR sg13_hv_pmos L=1.2u W=1.2u AS=0.408p AD=0.228p
+ PS=3.08u PD=1.58u rfmode=0
M$782 \$I395 \$I386 \$I368 VAPWR sg13_hv_pmos L=0.6u W=1.2u AS=0.228p AD=0.408p
+ PS=1.58u PD=3.08u rfmode=0
M$783 VAPWR \$I387 \$I385 VAPWR sg13_hv_pmos L=1.2u W=9.6u AS=2.544p AD=2.544p
+ PS=18.64u PD=18.64u rfmode=0
M$784 \$I385 \$I386 \$I378 VAPWR sg13_hv_pmos L=0.6u W=9.6u AS=2.544p AD=2.544p
+ PS=18.64u PD=18.64u rfmode=0
M$797 \$I372 \$I386 \$I392 VAPWR sg13_hv_pmos L=0.6u W=1.2u AS=0.408p AD=0.228p
+ PS=3.08u PD=1.58u rfmode=0
M$798 \$I392 \$I387 VAPWR VAPWR sg13_hv_pmos L=1.2u W=1.2u AS=0.228p AD=0.408p
+ PS=1.58u PD=3.08u rfmode=0
M$805 \$I387 \$I386 \$I393 VAPWR sg13_hv_pmos L=0.6u W=1.2u AS=0.408p AD=0.228p
+ PS=3.08u PD=1.58u rfmode=0
M$806 \$I393 \$I387 VAPWR VAPWR sg13_hv_pmos L=1.2u W=1.2u AS=0.228p AD=0.408p
+ PS=1.58u PD=3.08u rfmode=0
M$813 \$I369 \$I386 \$I394 VAPWR sg13_hv_pmos L=0.6u W=1.2u AS=0.408p AD=0.228p
+ PS=3.08u PD=1.58u rfmode=0
M$814 \$I394 \$I387 VAPWR VAPWR sg13_hv_pmos L=1.2u W=1.2u AS=0.228p AD=0.408p
+ PS=1.58u PD=3.08u rfmode=0
M$823 \$I380 VGND VAPWR VAPWR sg13_hv_pmos L=0.6u W=1.2u AS=0.408p AD=0.228p
+ PS=3.08u PD=1.58u rfmode=0
M$824 VAPWR \$I380 \$I386 VAPWR sg13_hv_pmos L=0.6u W=1.2u AS=0.228p AD=0.408p
+ PS=1.58u PD=3.08u rfmode=0
M$825 \$I371 \$I380 VAPWR VAPWR sg13_hv_pmos L=0.6u W=1.2u AS=0.408p AD=0.228p
+ PS=3.08u PD=1.58u rfmode=0
M$826 VAPWR \$I380 \$I378 VAPWR sg13_hv_pmos L=0.6u W=1.2u AS=0.228p AD=0.408p
+ PS=1.58u PD=3.08u rfmode=0
M$827 \$I261 VGND VGND VGND sg13_hv_nmos L=0.45u W=0.3u AS=0.102p AD=0.102p
+ PS=1.28u PD=1.28u rfmode=0
M$828 \$I282 \$I73 VGND VGND sg13_hv_nmos L=0.45u W=0.3u AS=0.102p AD=0.102p
+ PS=1.28u PD=1.28u rfmode=0
M$829 \$I303 VGND VGND VGND sg13_hv_nmos L=0.45u W=0.3u AS=0.102p AD=0.102p
+ PS=1.28u PD=1.28u rfmode=0
M$830 \$I260 VGND analog_1 VAPWR sg13_hv_pmos L=0.45u W=2u AS=0.68p AD=0.68p
+ PS=4.68u PD=4.68u rfmode=0
M$831 \$I281 \$I73 \$I94 VAPWR sg13_hv_pmos L=0.45u W=2u AS=0.68p AD=0.68p
+ PS=4.68u PD=4.68u rfmode=0
M$832 \$I302 VGND analog_2 VAPWR sg13_hv_pmos L=0.45u W=2u AS=0.68p AD=0.68p
+ PS=4.68u PD=4.68u rfmode=0
M$833 analog_1 \$I261 \$I260 VGND sg13_hv_nmos L=0.45u W=1u AS=0.34p AD=0.34p
+ PS=2.68u PD=2.68u rfmode=0
M$834 \$I94 \$I282 \$I281 VGND sg13_hv_nmos L=0.45u W=1u AS=0.34p AD=0.34p
+ PS=2.68u PD=2.68u rfmode=0
M$835 analog_2 \$I303 \$I302 VGND sg13_hv_nmos L=0.45u W=1u AS=0.34p AD=0.34p
+ PS=2.68u PD=2.68u rfmode=0
M$836 VAPWR VGND \$I261 VAPWR sg13_hv_pmos L=0.45u W=0.6u AS=0.204p AD=0.204p
+ PS=1.88u PD=1.88u rfmode=0
M$837 VAPWR \$I73 \$I282 VAPWR sg13_hv_pmos L=0.45u W=0.6u AS=0.204p AD=0.204p
+ PS=1.88u PD=1.88u rfmode=0
M$838 VAPWR VGND \$I303 VAPWR sg13_hv_pmos L=0.45u W=0.6u AS=0.204p AD=0.204p
+ PS=1.88u PD=1.88u rfmode=0
R$839 VGND VGND VGND rhigh w=0.5u l=14u ps=0u b=0 m=3
R$840 \$I257 \$I260 VGND rhigh w=0.5u l=14u ps=0u b=0 m=1
R$842 \$I278 \$I281 VGND rhigh w=0.5u l=14u ps=0u b=0 m=1
R$844 \$I299 \$I302 VGND rhigh w=0.5u l=14u ps=0u b=0 m=1
R$845 VGND VGND VGND rhigh w=0.5u l=15u ps=0u b=0 m=6
R$847 \$I249 \$I80 VGND rhigh w=0.5u l=30u ps=0u b=0 m=1
R$848 \$I245 \$I76 VGND rhigh w=0.5u l=30u ps=0u b=0 m=1
R$849 \$I243 \$I74 VGND rhigh w=0.5u l=30u ps=0u b=0 m=1
R$850 \$I243 \$I245 VGND rhigh w=0.5u l=15u ps=0u b=0 m=1
R$851 \$I255 \$I86 VGND rhigh w=0.5u l=30u ps=0u b=0 m=1
R$852 VGND \$I243 VGND rhigh w=0.5u l=45u ps=0u b=0 m=1
R$855 \$I247 \$I78 VGND rhigh w=0.5u l=30u ps=0u b=0 m=1
R$856 \$I257 \$I88 VGND rhigh w=0.5u l=30u ps=0u b=0 m=1
R$860 \$I255 \$I257 VGND rhigh w=0.5u l=15u ps=0u b=0 m=1
R$861 \$I253 \$I255 VGND rhigh w=0.5u l=15u ps=0u b=0 m=1
R$863 \$I253 \$I84 VGND rhigh w=0.5u l=30u ps=0u b=0 m=1
R$865 \$I251 \$I82 VGND rhigh w=0.5u l=30u ps=0u b=0 m=1
R$866 \$I251 \$I253 VGND rhigh w=0.5u l=15u ps=0u b=0 m=1
R$867 \$I249 \$I251 VGND rhigh w=0.5u l=15u ps=0u b=0 m=1
R$870 \$I247 \$I249 VGND rhigh w=0.5u l=15u ps=0u b=0 m=1
R$871 \$I245 \$I247 VGND rhigh w=0.5u l=15u ps=0u b=0 m=1
R$875 \$I270 \$I81 VGND rhigh w=0.5u l=30u ps=0u b=0 m=1
R$876 \$I266 \$I77 VGND rhigh w=0.5u l=30u ps=0u b=0 m=1
R$877 \$I264 \$I75 VGND rhigh w=0.5u l=30u ps=0u b=0 m=1
R$878 \$I264 \$I266 VGND rhigh w=0.5u l=15u ps=0u b=0 m=1
R$879 \$I276 \$I87 VGND rhigh w=0.5u l=30u ps=0u b=0 m=1
R$880 VGND \$I264 VGND rhigh w=0.5u l=45u ps=0u b=0 m=1
R$883 \$I268 \$I79 VGND rhigh w=0.5u l=30u ps=0u b=0 m=1
R$884 \$I278 \$I89 VGND rhigh w=0.5u l=30u ps=0u b=0 m=1
R$888 \$I276 \$I278 VGND rhigh w=0.5u l=15u ps=0u b=0 m=1
R$889 \$I274 \$I276 VGND rhigh w=0.5u l=15u ps=0u b=0 m=1
R$891 \$I274 \$I85 VGND rhigh w=0.5u l=30u ps=0u b=0 m=1
R$893 \$I272 \$I83 VGND rhigh w=0.5u l=30u ps=0u b=0 m=1
R$894 \$I272 \$I274 VGND rhigh w=0.5u l=15u ps=0u b=0 m=1
R$895 \$I270 \$I272 VGND rhigh w=0.5u l=15u ps=0u b=0 m=1
R$898 \$I268 \$I270 VGND rhigh w=0.5u l=15u ps=0u b=0 m=1
R$899 \$I266 \$I268 VGND rhigh w=0.5u l=15u ps=0u b=0 m=1
R$903 \$I291 \$I45 VGND rhigh w=0.5u l=30u ps=0u b=0 m=1
R$904 \$I287 \$I39 VGND rhigh w=0.5u l=30u ps=0u b=0 m=1
R$905 \$I285 \$I36 VGND rhigh w=0.5u l=30u ps=0u b=0 m=1
R$906 \$I285 \$I287 VGND rhigh w=0.5u l=15u ps=0u b=0 m=1
R$907 \$I297 \$I54 VGND rhigh w=0.5u l=30u ps=0u b=0 m=1
R$908 VGND \$I285 VGND rhigh w=0.5u l=45u ps=0u b=0 m=1
R$911 \$I289 \$I42 VGND rhigh w=0.5u l=30u ps=0u b=0 m=1
R$912 \$I299 \$I57 VGND rhigh w=0.5u l=30u ps=0u b=0 m=1
R$916 \$I297 \$I299 VGND rhigh w=0.5u l=15u ps=0u b=0 m=1
R$917 \$I295 \$I297 VGND rhigh w=0.5u l=15u ps=0u b=0 m=1
R$919 \$I295 \$I51 VGND rhigh w=0.5u l=30u ps=0u b=0 m=1
R$921 \$I293 \$I48 VGND rhigh w=0.5u l=30u ps=0u b=0 m=1
R$922 \$I293 \$I295 VGND rhigh w=0.5u l=15u ps=0u b=0 m=1
R$923 \$I291 \$I293 VGND rhigh w=0.5u l=15u ps=0u b=0 m=1
R$926 \$I289 \$I291 VGND rhigh w=0.5u l=15u ps=0u b=0 m=1
R$927 \$I287 \$I289 VGND rhigh w=0.5u l=15u ps=0u b=0 m=1
M$929 \$16.SH_IN \$I144 \$16.SH_IN \$16.VDD sg13_hv_pmos L=0.45u W=0.9u
+ AS=0.306p AD=0.171p PS=2.48u PD=1.28u rfmode=0
M$930 \$16.SH_IN \$I143 \$16.SH_OUT \$16.VDD sg13_hv_pmos L=0.45u W=1.8u
+ AS=0.342p AD=0.477p PS=2.56u PD=3.76u rfmode=0
M$931 \$16.SH_OUT \$I144 \$16.SH_OUT \$16.VDD sg13_hv_pmos L=0.45u W=0.9u
+ AS=0.171p AD=0.171p PS=1.28u PD=1.28u rfmode=0
M$933 \$16.SH_IN \$I143 \$16.SH_IN VGND sg13_hv_nmos L=0.45u W=0.3u AS=0.102p
+ AD=0.057p PS=1.28u PD=0.68u rfmode=0
M$934 \$16.SH_IN \$I142 \$16.SH_OUT VGND sg13_hv_nmos L=0.45u W=0.6u AS=0.114p
+ AD=0.159p PS=1.36u PD=1.96u rfmode=0
M$935 \$16.SH_OUT \$I143 \$16.SH_OUT VGND sg13_hv_nmos L=0.45u W=0.3u AS=0.057p
+ AD=0.057p PS=0.68u PD=0.68u rfmode=0
M$937 \$16.VDD \$16.SH_EN \$I304 \$16.VDD sg13_hv_pmos L=0.45u W=1.2u AS=0.408p
+ AD=0.408p PS=3.08u PD=3.08u rfmode=0
M$938 \$16.VDD \$I304 \$I142 \$16.VDD sg13_hv_pmos L=0.45u W=1.2u AS=0.408p
+ AD=0.408p PS=3.08u PD=3.08u rfmode=0
M$939 VGND \$16.SH_EN \$I304 VGND sg13_hv_nmos L=0.45u W=0.6u AS=0.204p
+ AD=0.204p PS=1.88u PD=1.88u rfmode=0
M$940 VGND \$I304 \$I142 VGND sg13_hv_nmos L=0.45u W=0.6u AS=0.204p AD=0.204p
+ PS=1.88u PD=1.88u rfmode=0
M$941 \$16.VDD \$I142 \$I143 \$16.VDD sg13_hv_pmos L=0.45u W=2.4u AS=0.636p
+ AD=0.636p PS=4.66u PD=4.66u rfmode=0
M$943 \$16.VDD \$I143 \$I144 \$16.VDD sg13_hv_pmos L=0.45u W=2.4u AS=0.636p
+ AD=0.636p PS=4.66u PD=4.66u rfmode=0
M$945 VGND \$I142 \$I143 VGND sg13_hv_nmos L=0.45u W=1.2u AS=0.318p AD=0.318p
+ PS=2.86u PD=2.86u rfmode=0
M$947 VGND \$I143 \$I144 VGND sg13_hv_nmos L=0.45u W=1.2u AS=0.318p AD=0.318p
+ PS=2.86u PD=2.86u rfmode=0
M$950 \$I313 \$I313 VGND VGND sg13_hv_nmos L=0.6u W=1.2u AS=0.408p AD=0.408p
+ PS=3.08u PD=3.08u rfmode=0
M$952 \$I310 \$I310 \$I313 VGND sg13_hv_nmos L=0.6u W=1.2u AS=0.408p AD=0.408p
+ PS=3.08u PD=3.08u rfmode=0
M$954 \$I344 \$I344 VGND VGND sg13_hv_nmos L=0.6u W=1.2u AS=0.408p AD=0.408p
+ PS=3.08u PD=3.08u rfmode=0
M$956 \$I341 \$I341 \$I344 VGND sg13_hv_nmos L=0.6u W=1.2u AS=0.408p AD=0.408p
+ PS=3.08u PD=3.08u rfmode=0
M$958 \$I375 \$I375 VGND VGND sg13_hv_nmos L=0.6u W=1.2u AS=0.408p AD=0.408p
+ PS=3.08u PD=3.08u rfmode=0
M$960 \$I372 \$I372 \$I375 VGND sg13_hv_nmos L=0.6u W=1.2u AS=0.408p AD=0.408p
+ PS=3.08u PD=3.08u rfmode=0
M$961 analog_1 \$I314 VGND VGND sg13_hv_nmos L=0.6u W=48u AS=16.32p AD=16.32p
+ PS=123.2u PD=123.2u rfmode=0
M$1017 \$I314 \$I310 \$I316 VGND sg13_hv_nmos L=0.6u W=4.8u AS=1.632p AD=1.632p
+ PS=12.32u PD=12.32u rfmode=0
M$1021 \$I94 \$I345 VGND VGND sg13_hv_nmos L=0.6u W=48u AS=16.32p AD=16.32p
+ PS=123.2u PD=123.2u rfmode=0
M$1077 \$I345 \$I341 \$I347 VGND sg13_hv_nmos L=0.6u W=4.8u AS=1.632p AD=1.632p
+ PS=12.32u PD=12.32u rfmode=0
M$1081 analog_2 \$I376 VGND VGND sg13_hv_nmos L=0.6u W=48u AS=16.32p AD=16.32p
+ PS=123.2u PD=123.2u rfmode=0
M$1137 \$I376 \$I372 \$I378 VGND sg13_hv_nmos L=0.6u W=4.8u AS=1.632p AD=1.632p
+ PS=12.32u PD=12.32u rfmode=0
M$1141 VGND \$I306 VGND VGND sg13_hv_nmos L=10u W=0.8u AS=0.272p AD=0.272p
+ PS=2.96u PD=2.96u rfmode=0
M$1142 \$I305 \$I306 VGND VGND sg13_hv_nmos L=10u W=0.4u AS=0.136p AD=0.136p
+ PS=1.48u PD=1.48u rfmode=0
M$1144 \$I306 \$I306 \$I321 VGND sg13_hv_nmos L=10u W=0.4u AS=0.136p AD=0.136p
+ PS=1.48u PD=1.48u rfmode=0
M$1145 \$I321 \$I306 \$I320 VGND sg13_hv_nmos L=10u W=0.4u AS=0.136p AD=0.136p
+ PS=1.48u PD=1.48u rfmode=0
M$1146 \$I320 \$I306 \$I317 VGND sg13_hv_nmos L=10u W=0.4u AS=0.136p AD=0.136p
+ PS=1.48u PD=1.48u rfmode=0
M$1147 \$I317 \$I306 \$I305 VGND sg13_hv_nmos L=10u W=0.4u AS=0.136p AD=0.136p
+ PS=1.48u PD=1.48u rfmode=0
M$1148 VGND \$I337 VGND VGND sg13_hv_nmos L=10u W=0.8u AS=0.272p AD=0.272p
+ PS=2.96u PD=2.96u rfmode=0
M$1149 \$I336 \$I337 VGND VGND sg13_hv_nmos L=10u W=0.4u AS=0.136p AD=0.136p
+ PS=1.48u PD=1.48u rfmode=0
M$1151 \$I337 \$I337 \$I352 VGND sg13_hv_nmos L=10u W=0.4u AS=0.136p AD=0.136p
+ PS=1.48u PD=1.48u rfmode=0
M$1152 \$I352 \$I337 \$I351 VGND sg13_hv_nmos L=10u W=0.4u AS=0.136p AD=0.136p
+ PS=1.48u PD=1.48u rfmode=0
M$1153 \$I351 \$I337 \$I348 VGND sg13_hv_nmos L=10u W=0.4u AS=0.136p AD=0.136p
+ PS=1.48u PD=1.48u rfmode=0
M$1154 \$I348 \$I337 \$I336 VGND sg13_hv_nmos L=10u W=0.4u AS=0.136p AD=0.136p
+ PS=1.48u PD=1.48u rfmode=0
M$1155 VGND \$I368 VGND VGND sg13_hv_nmos L=10u W=0.8u AS=0.272p AD=0.272p
+ PS=2.96u PD=2.96u rfmode=0
M$1156 \$I367 \$I368 VGND VGND sg13_hv_nmos L=10u W=0.4u AS=0.136p AD=0.136p
+ PS=1.48u PD=1.48u rfmode=0
M$1158 \$I368 \$I368 \$I383 VGND sg13_hv_nmos L=10u W=0.4u AS=0.136p AD=0.136p
+ PS=1.48u PD=1.48u rfmode=0
M$1159 \$I383 \$I368 \$I382 VGND sg13_hv_nmos L=10u W=0.4u AS=0.136p AD=0.136p
+ PS=1.48u PD=1.48u rfmode=0
M$1160 \$I382 \$I368 \$I379 VGND sg13_hv_nmos L=10u W=0.4u AS=0.136p AD=0.136p
+ PS=1.48u PD=1.48u rfmode=0
M$1161 \$I379 \$I368 \$I367 VGND sg13_hv_nmos L=10u W=0.4u AS=0.136p AD=0.136p
+ PS=1.48u PD=1.48u rfmode=0
M$1162 \$I326 \$I324 \$I324 VAPWR sg13_hv_pmos L=10u W=1u AS=0.34p AD=0.34p
+ PS=2.68u PD=2.68u rfmode=0
M$1163 VAPWR \$I324 VAPWR VAPWR sg13_hv_pmos L=10u W=2u AS=0.68p AD=0.68p
+ PS=5.36u PD=5.36u rfmode=0
M$1164 VAPWR \$I324 \$I328 VAPWR sg13_hv_pmos L=10u W=1u AS=0.34p AD=0.34p
+ PS=2.68u PD=2.68u rfmode=0
M$1165 \$I328 \$I324 \$I327 VAPWR sg13_hv_pmos L=10u W=1u AS=0.34p AD=0.34p
+ PS=2.68u PD=2.68u rfmode=0
M$1167 \$I327 \$I324 \$I326 VAPWR sg13_hv_pmos L=10u W=1u AS=0.34p AD=0.34p
+ PS=2.68u PD=2.68u rfmode=0
M$1168 \$I357 \$I355 \$I355 VAPWR sg13_hv_pmos L=10u W=1u AS=0.34p AD=0.34p
+ PS=2.68u PD=2.68u rfmode=0
M$1169 VAPWR \$I355 VAPWR VAPWR sg13_hv_pmos L=10u W=2u AS=0.68p AD=0.68p
+ PS=5.36u PD=5.36u rfmode=0
M$1170 VAPWR \$I355 \$I359 VAPWR sg13_hv_pmos L=10u W=1u AS=0.34p AD=0.34p
+ PS=2.68u PD=2.68u rfmode=0
M$1171 \$I359 \$I355 \$I358 VAPWR sg13_hv_pmos L=10u W=1u AS=0.34p AD=0.34p
+ PS=2.68u PD=2.68u rfmode=0
M$1173 \$I358 \$I355 \$I357 VAPWR sg13_hv_pmos L=10u W=1u AS=0.34p AD=0.34p
+ PS=2.68u PD=2.68u rfmode=0
M$1174 \$I388 \$I386 \$I386 VAPWR sg13_hv_pmos L=10u W=1u AS=0.34p AD=0.34p
+ PS=2.68u PD=2.68u rfmode=0
M$1175 VAPWR \$I386 VAPWR VAPWR sg13_hv_pmos L=10u W=2u AS=0.68p AD=0.68p
+ PS=5.36u PD=5.36u rfmode=0
M$1176 VAPWR \$I386 \$I390 VAPWR sg13_hv_pmos L=10u W=1u AS=0.34p AD=0.34p
+ PS=2.68u PD=2.68u rfmode=0
M$1177 \$I390 \$I386 \$I389 VAPWR sg13_hv_pmos L=10u W=1u AS=0.34p AD=0.34p
+ PS=2.68u PD=2.68u rfmode=0
M$1179 \$I389 \$I386 \$I388 VAPWR sg13_hv_pmos L=10u W=1u AS=0.34p AD=0.34p
+ PS=2.68u PD=2.68u rfmode=0
M$1204 analog_1 \$I316 VAPWR VAPWR sg13_hv_pmos L=0.4u W=96u AS=32.64p
+ AD=32.64p PS=219.2u PD=219.2u rfmode=0
M$1205 VAPWR VAPWR VAPWR VAPWR sg13_hv_pmos L=0.4u W=129.6u AS=44.064p
+ AD=44.064p PS=295.92u PD=295.92u rfmode=0
M$1248 \$I329 \$I309 \$I309 VAPWR sg13_hv_pmos L=0.4u W=2.4u AS=0.816p
+ AD=0.816p PS=5.48u PD=5.48u rfmode=0
M$1249 \$I314 \$I309 \$I316 VAPWR sg13_hv_pmos L=0.4u W=9.6u AS=3.264p
+ AD=3.264p PS=21.92u PD=21.92u rfmode=0
M$1266 VAPWR \$I329 \$I329 VAPWR sg13_hv_pmos L=0.4u W=2.4u AS=0.816p AD=0.816p
+ PS=5.48u PD=5.48u rfmode=0
M$1268 \$I94 \$I347 VAPWR VAPWR sg13_hv_pmos L=0.4u W=96u AS=32.64p AD=32.64p
+ PS=219.2u PD=219.2u rfmode=0
M$1312 \$I360 \$I340 \$I340 VAPWR sg13_hv_pmos L=0.4u W=2.4u AS=0.816p
+ AD=0.816p PS=5.48u PD=5.48u rfmode=0
M$1313 \$I345 \$I340 \$I347 VAPWR sg13_hv_pmos L=0.4u W=9.6u AS=3.264p
+ AD=3.264p PS=21.92u PD=21.92u rfmode=0
M$1330 VAPWR \$I360 \$I360 VAPWR sg13_hv_pmos L=0.4u W=2.4u AS=0.816p AD=0.816p
+ PS=5.48u PD=5.48u rfmode=0
M$1332 analog_2 \$I378 VAPWR VAPWR sg13_hv_pmos L=0.4u W=96u AS=32.64p
+ AD=32.64p PS=219.2u PD=219.2u rfmode=0
M$1376 \$I391 \$I371 \$I371 VAPWR sg13_hv_pmos L=0.4u W=2.4u AS=0.816p
+ AD=0.816p PS=5.48u PD=5.48u rfmode=0
M$1377 \$I376 \$I371 \$I378 VAPWR sg13_hv_pmos L=0.4u W=9.6u AS=3.264p
+ AD=3.264p PS=21.92u PD=21.92u rfmode=0
M$1394 VAPWR \$I391 \$I391 VAPWR sg13_hv_pmos L=0.4u W=2.4u AS=0.816p AD=0.816p
+ PS=5.48u PD=5.48u rfmode=0
M$1400 \$I319 \$I124 \$I323 VGND sg13_hv_nmos L=0.45u W=4.8u AS=1.632p
+ AD=1.632p PS=10.96u PD=10.96u rfmode=0
M$1401 \$I319 \$I257 \$I322 VGND sg13_hv_nmos L=0.45u W=4.8u AS=1.632p
+ AD=1.632p PS=10.96u PD=10.96u rfmode=0
M$1408 \$I350 \$I124 \$I354 VGND sg13_hv_nmos L=0.45u W=4.8u AS=1.632p
+ AD=1.632p PS=10.96u PD=10.96u rfmode=0
M$1409 \$I350 \$I278 \$I353 VGND sg13_hv_nmos L=0.45u W=4.8u AS=1.632p
+ AD=1.632p PS=10.96u PD=10.96u rfmode=0
M$1416 \$I381 \$I124 \$I385 VGND sg13_hv_nmos L=0.45u W=4.8u AS=1.632p
+ AD=1.632p PS=10.96u PD=10.96u rfmode=0
M$1417 \$I381 \$I299 \$I384 VGND sg13_hv_nmos L=0.45u W=4.8u AS=1.632p
+ AD=1.632p PS=10.96u PD=10.96u rfmode=0
M$1420 \$I400 \$I402 VPWR VPWR sg13_lv_pmos L=0.13u W=0.3u AS=0.102p AD=0.102p
+ PS=1.28u PD=1.28u rfmode=0
M$1421 \$I402 dac_out[11] VPWR VPWR sg13_lv_pmos L=0.13u W=0.3u AS=0.102p
+ AD=0.102p PS=1.28u PD=1.28u rfmode=0
M$1422 \$I399 \$I400 VPWR VPWR sg13_lv_pmos L=0.13u W=0.3u AS=0.102p AD=0.102p
+ PS=1.28u PD=1.28u rfmode=0
M$1423 \$I405 \$I407 VPWR VPWR sg13_lv_pmos L=0.13u W=0.3u AS=0.102p AD=0.102p
+ PS=1.28u PD=1.28u rfmode=0
M$1424 \$I407 dac_out[14] VPWR VPWR sg13_lv_pmos L=0.13u W=0.3u AS=0.102p
+ AD=0.102p PS=1.28u PD=1.28u rfmode=0
M$1425 \$I404 \$I405 VPWR VPWR sg13_lv_pmos L=0.13u W=0.3u AS=0.102p AD=0.102p
+ PS=1.28u PD=1.28u rfmode=0
M$1426 \$I410 \$I412 VPWR VPWR sg13_lv_pmos L=0.13u W=0.3u AS=0.102p AD=0.102p
+ PS=1.28u PD=1.28u rfmode=0
M$1427 \$I412 dac_out[12] VPWR VPWR sg13_lv_pmos L=0.13u W=0.3u AS=0.102p
+ AD=0.102p PS=1.28u PD=1.28u rfmode=0
M$1428 \$I409 \$I410 VPWR VPWR sg13_lv_pmos L=0.13u W=0.3u AS=0.102p AD=0.102p
+ PS=1.28u PD=1.28u rfmode=0
M$1429 \$I415 \$I417 VPWR VPWR sg13_lv_pmos L=0.13u W=0.3u AS=0.102p AD=0.102p
+ PS=1.28u PD=1.28u rfmode=0
M$1430 \$I417 dac_out[10] VPWR VPWR sg13_lv_pmos L=0.13u W=0.3u AS=0.102p
+ AD=0.102p PS=1.28u PD=1.28u rfmode=0
M$1431 \$I414 \$I415 VPWR VPWR sg13_lv_pmos L=0.13u W=0.3u AS=0.102p AD=0.102p
+ PS=1.28u PD=1.28u rfmode=0
M$1432 \$I420 \$I422 VPWR VPWR sg13_lv_pmos L=0.13u W=0.3u AS=0.102p AD=0.102p
+ PS=1.28u PD=1.28u rfmode=0
M$1433 \$I422 dac_out[8] VPWR VPWR sg13_lv_pmos L=0.13u W=0.3u AS=0.102p
+ AD=0.102p PS=1.28u PD=1.28u rfmode=0
M$1434 \$I419 \$I420 VPWR VPWR sg13_lv_pmos L=0.13u W=0.3u AS=0.102p AD=0.102p
+ PS=1.28u PD=1.28u rfmode=0
M$1435 \$I425 \$I427 VPWR VPWR sg13_lv_pmos L=0.13u W=0.3u AS=0.102p AD=0.102p
+ PS=1.28u PD=1.28u rfmode=0
M$1436 \$I427 dac_out[13] VPWR VPWR sg13_lv_pmos L=0.13u W=0.3u AS=0.102p
+ AD=0.102p PS=1.28u PD=1.28u rfmode=0
M$1437 \$I424 \$I425 VPWR VPWR sg13_lv_pmos L=0.13u W=0.3u AS=0.102p AD=0.102p
+ PS=1.28u PD=1.28u rfmode=0
M$1438 \$I430 \$I432 VPWR VPWR sg13_lv_pmos L=0.13u W=0.3u AS=0.102p AD=0.102p
+ PS=1.28u PD=1.28u rfmode=0
M$1439 \$I432 dac_out[9] VPWR VPWR sg13_lv_pmos L=0.13u W=0.3u AS=0.102p
+ AD=0.102p PS=1.28u PD=1.28u rfmode=0
M$1440 \$I429 \$I430 VPWR VPWR sg13_lv_pmos L=0.13u W=0.3u AS=0.102p AD=0.102p
+ PS=1.28u PD=1.28u rfmode=0
M$1441 \$I435 \$I437 VPWR VPWR sg13_lv_pmos L=0.13u W=0.3u AS=0.102p AD=0.102p
+ PS=1.28u PD=1.28u rfmode=0
M$1442 \$I437 dac_out[15] VPWR VPWR sg13_lv_pmos L=0.13u W=0.3u AS=0.102p
+ AD=0.102p PS=1.28u PD=1.28u rfmode=0
M$1443 \$I434 \$I435 VPWR VPWR sg13_lv_pmos L=0.13u W=0.3u AS=0.102p AD=0.102p
+ PS=1.28u PD=1.28u rfmode=0
M$1444 \$I440 \$I442 VPWR VPWR sg13_lv_pmos L=0.13u W=0.3u AS=0.102p AD=0.102p
+ PS=1.28u PD=1.28u rfmode=0
M$1445 \$I442 \$I20 VPWR VPWR sg13_lv_pmos L=0.13u W=0.3u AS=0.102p AD=0.102p
+ PS=1.28u PD=1.28u rfmode=0
M$1446 \$I439 \$I440 VPWR VPWR sg13_lv_pmos L=0.13u W=0.3u AS=0.102p AD=0.102p
+ PS=1.28u PD=1.28u rfmode=0
M$1447 \$I445 \$I447 VPWR VPWR sg13_lv_pmos L=0.13u W=0.3u AS=0.102p AD=0.102p
+ PS=1.28u PD=1.28u rfmode=0
M$1448 \$I447 \$I29 VPWR VPWR sg13_lv_pmos L=0.13u W=0.3u AS=0.102p AD=0.102p
+ PS=1.28u PD=1.28u rfmode=0
M$1449 \$I444 \$I445 VPWR VPWR sg13_lv_pmos L=0.13u W=0.3u AS=0.102p AD=0.102p
+ PS=1.28u PD=1.28u rfmode=0
M$1450 \$I450 \$I452 VPWR VPWR sg13_lv_pmos L=0.13u W=0.3u AS=0.102p AD=0.102p
+ PS=1.28u PD=1.28u rfmode=0
M$1451 \$I452 \$I23 VPWR VPWR sg13_lv_pmos L=0.13u W=0.3u AS=0.102p AD=0.102p
+ PS=1.28u PD=1.28u rfmode=0
M$1452 \$I449 \$I450 VPWR VPWR sg13_lv_pmos L=0.13u W=0.3u AS=0.102p AD=0.102p
+ PS=1.28u PD=1.28u rfmode=0
M$1453 \$I455 \$I457 VPWR VPWR sg13_lv_pmos L=0.13u W=0.3u AS=0.102p AD=0.102p
+ PS=1.28u PD=1.28u rfmode=0
M$1454 \$I457 \$I17 VPWR VPWR sg13_lv_pmos L=0.13u W=0.3u AS=0.102p AD=0.102p
+ PS=1.28u PD=1.28u rfmode=0
M$1455 \$I454 \$I455 VPWR VPWR sg13_lv_pmos L=0.13u W=0.3u AS=0.102p AD=0.102p
+ PS=1.28u PD=1.28u rfmode=0
M$1456 \$I460 \$I462 VPWR VPWR sg13_lv_pmos L=0.13u W=0.3u AS=0.102p AD=0.102p
+ PS=1.28u PD=1.28u rfmode=0
M$1457 \$I462 \$I11 VPWR VPWR sg13_lv_pmos L=0.13u W=0.3u AS=0.102p AD=0.102p
+ PS=1.28u PD=1.28u rfmode=0
M$1458 \$I459 \$I460 VPWR VPWR sg13_lv_pmos L=0.13u W=0.3u AS=0.102p AD=0.102p
+ PS=1.28u PD=1.28u rfmode=0
M$1459 \$I465 \$I467 VPWR VPWR sg13_lv_pmos L=0.13u W=0.3u AS=0.102p AD=0.102p
+ PS=1.28u PD=1.28u rfmode=0
M$1460 \$I467 \$I26 VPWR VPWR sg13_lv_pmos L=0.13u W=0.3u AS=0.102p AD=0.102p
+ PS=1.28u PD=1.28u rfmode=0
M$1461 \$I464 \$I465 VPWR VPWR sg13_lv_pmos L=0.13u W=0.3u AS=0.102p AD=0.102p
+ PS=1.28u PD=1.28u rfmode=0
M$1462 \$I470 \$I472 VPWR VPWR sg13_lv_pmos L=0.13u W=0.3u AS=0.102p AD=0.102p
+ PS=1.28u PD=1.28u rfmode=0
M$1463 \$I472 \$I14 VPWR VPWR sg13_lv_pmos L=0.13u W=0.3u AS=0.102p AD=0.102p
+ PS=1.28u PD=1.28u rfmode=0
M$1464 \$I469 \$I470 VPWR VPWR sg13_lv_pmos L=0.13u W=0.3u AS=0.102p AD=0.102p
+ PS=1.28u PD=1.28u rfmode=0
M$1465 \$I475 \$I477 VPWR VPWR sg13_lv_pmos L=0.13u W=0.3u AS=0.102p AD=0.102p
+ PS=1.28u PD=1.28u rfmode=0
M$1466 \$I477 \$I32 VPWR VPWR sg13_lv_pmos L=0.13u W=0.3u AS=0.102p AD=0.102p
+ PS=1.28u PD=1.28u rfmode=0
M$1467 \$I474 \$I475 VPWR VPWR sg13_lv_pmos L=0.13u W=0.3u AS=0.102p AD=0.102p
+ PS=1.28u PD=1.28u rfmode=0
M$1468 \$I480 \$I482 VPWR VPWR sg13_lv_pmos L=0.13u W=0.3u AS=0.102p AD=0.102p
+ PS=1.28u PD=1.28u rfmode=0
M$1469 \$I482 dac_out[3] VPWR VPWR sg13_lv_pmos L=0.13u W=0.3u AS=0.102p
+ AD=0.102p PS=1.28u PD=1.28u rfmode=0
M$1470 \$I479 \$I480 VPWR VPWR sg13_lv_pmos L=0.13u W=0.3u AS=0.102p AD=0.102p
+ PS=1.28u PD=1.28u rfmode=0
M$1471 \$I485 \$I487 VPWR VPWR sg13_lv_pmos L=0.13u W=0.3u AS=0.102p AD=0.102p
+ PS=1.28u PD=1.28u rfmode=0
M$1472 \$I487 dac_out[6] VPWR VPWR sg13_lv_pmos L=0.13u W=0.3u AS=0.102p
+ AD=0.102p PS=1.28u PD=1.28u rfmode=0
M$1473 \$I484 \$I485 VPWR VPWR sg13_lv_pmos L=0.13u W=0.3u AS=0.102p AD=0.102p
+ PS=1.28u PD=1.28u rfmode=0
M$1474 \$I490 \$I492 VPWR VPWR sg13_lv_pmos L=0.13u W=0.3u AS=0.102p AD=0.102p
+ PS=1.28u PD=1.28u rfmode=0
M$1475 \$I492 dac_out[4] VPWR VPWR sg13_lv_pmos L=0.13u W=0.3u AS=0.102p
+ AD=0.102p PS=1.28u PD=1.28u rfmode=0
M$1476 \$I489 \$I490 VPWR VPWR sg13_lv_pmos L=0.13u W=0.3u AS=0.102p AD=0.102p
+ PS=1.28u PD=1.28u rfmode=0
M$1477 \$I495 \$I497 VPWR VPWR sg13_lv_pmos L=0.13u W=0.3u AS=0.102p AD=0.102p
+ PS=1.28u PD=1.28u rfmode=0
M$1478 \$I497 dac_out[2] VPWR VPWR sg13_lv_pmos L=0.13u W=0.3u AS=0.102p
+ AD=0.102p PS=1.28u PD=1.28u rfmode=0
M$1479 \$I494 \$I495 VPWR VPWR sg13_lv_pmos L=0.13u W=0.3u AS=0.102p AD=0.102p
+ PS=1.28u PD=1.28u rfmode=0
M$1480 \$I500 \$I502 VPWR VPWR sg13_lv_pmos L=0.13u W=0.3u AS=0.102p AD=0.102p
+ PS=1.28u PD=1.28u rfmode=0
M$1481 \$I502 dac_out[0] VPWR VPWR sg13_lv_pmos L=0.13u W=0.3u AS=0.102p
+ AD=0.102p PS=1.28u PD=1.28u rfmode=0
M$1482 \$I499 \$I500 VPWR VPWR sg13_lv_pmos L=0.13u W=0.3u AS=0.102p AD=0.102p
+ PS=1.28u PD=1.28u rfmode=0
M$1483 \$I505 \$I507 VPWR VPWR sg13_lv_pmos L=0.13u W=0.3u AS=0.102p AD=0.102p
+ PS=1.28u PD=1.28u rfmode=0
M$1484 \$I507 dac_out[5] VPWR VPWR sg13_lv_pmos L=0.13u W=0.3u AS=0.102p
+ AD=0.102p PS=1.28u PD=1.28u rfmode=0
M$1485 \$I504 \$I505 VPWR VPWR sg13_lv_pmos L=0.13u W=0.3u AS=0.102p AD=0.102p
+ PS=1.28u PD=1.28u rfmode=0
M$1486 \$I510 \$I512 VPWR VPWR sg13_lv_pmos L=0.13u W=0.3u AS=0.102p AD=0.102p
+ PS=1.28u PD=1.28u rfmode=0
M$1487 \$I512 dac_out[1] VPWR VPWR sg13_lv_pmos L=0.13u W=0.3u AS=0.102p
+ AD=0.102p PS=1.28u PD=1.28u rfmode=0
M$1488 \$I509 \$I510 VPWR VPWR sg13_lv_pmos L=0.13u W=0.3u AS=0.102p AD=0.102p
+ PS=1.28u PD=1.28u rfmode=0
M$1489 \$I515 \$I517 VPWR VPWR sg13_lv_pmos L=0.13u W=0.3u AS=0.102p AD=0.102p
+ PS=1.28u PD=1.28u rfmode=0
M$1490 \$I517 dac_out[7] VPWR VPWR sg13_lv_pmos L=0.13u W=0.3u AS=0.102p
+ AD=0.102p PS=1.28u PD=1.28u rfmode=0
M$1491 \$I514 \$I515 VPWR VPWR sg13_lv_pmos L=0.13u W=0.3u AS=0.102p AD=0.102p
+ PS=1.28u PD=1.28u rfmode=0
M$1492 VGND \$I402 \$I400 VGND sg13_lv_nmos L=0.13u W=0.15u AS=0.1005p
+ AD=0.1005p PS=1.34u PD=1.34u rfmode=0
M$1493 VGND dac_out[11] \$I402 VGND sg13_lv_nmos L=0.13u W=0.15u AS=0.1005p
+ AD=0.1005p PS=1.34u PD=1.34u rfmode=0
M$1494 VGND \$I400 \$I399 VGND sg13_lv_nmos L=0.13u W=0.15u AS=0.1005p
+ AD=0.1005p PS=1.34u PD=1.34u rfmode=0
M$1495 VGND \$I407 \$I405 VGND sg13_lv_nmos L=0.13u W=0.15u AS=0.1005p
+ AD=0.1005p PS=1.34u PD=1.34u rfmode=0
M$1496 VGND dac_out[14] \$I407 VGND sg13_lv_nmos L=0.13u W=0.15u AS=0.1005p
+ AD=0.1005p PS=1.34u PD=1.34u rfmode=0
M$1497 VGND \$I405 \$I404 VGND sg13_lv_nmos L=0.13u W=0.15u AS=0.1005p
+ AD=0.1005p PS=1.34u PD=1.34u rfmode=0
M$1498 VGND \$I412 \$I410 VGND sg13_lv_nmos L=0.13u W=0.15u AS=0.1005p
+ AD=0.1005p PS=1.34u PD=1.34u rfmode=0
M$1499 VGND dac_out[12] \$I412 VGND sg13_lv_nmos L=0.13u W=0.15u AS=0.1005p
+ AD=0.1005p PS=1.34u PD=1.34u rfmode=0
M$1500 VGND \$I410 \$I409 VGND sg13_lv_nmos L=0.13u W=0.15u AS=0.1005p
+ AD=0.1005p PS=1.34u PD=1.34u rfmode=0
M$1501 VGND \$I417 \$I415 VGND sg13_lv_nmos L=0.13u W=0.15u AS=0.1005p
+ AD=0.1005p PS=1.34u PD=1.34u rfmode=0
M$1502 VGND dac_out[10] \$I417 VGND sg13_lv_nmos L=0.13u W=0.15u AS=0.1005p
+ AD=0.1005p PS=1.34u PD=1.34u rfmode=0
M$1503 VGND \$I415 \$I414 VGND sg13_lv_nmos L=0.13u W=0.15u AS=0.1005p
+ AD=0.1005p PS=1.34u PD=1.34u rfmode=0
M$1504 VGND \$I422 \$I420 VGND sg13_lv_nmos L=0.13u W=0.15u AS=0.1005p
+ AD=0.1005p PS=1.34u PD=1.34u rfmode=0
M$1505 VGND dac_out[8] \$I422 VGND sg13_lv_nmos L=0.13u W=0.15u AS=0.1005p
+ AD=0.1005p PS=1.34u PD=1.34u rfmode=0
M$1506 VGND \$I420 \$I419 VGND sg13_lv_nmos L=0.13u W=0.15u AS=0.1005p
+ AD=0.1005p PS=1.34u PD=1.34u rfmode=0
M$1507 VGND \$I427 \$I425 VGND sg13_lv_nmos L=0.13u W=0.15u AS=0.1005p
+ AD=0.1005p PS=1.34u PD=1.34u rfmode=0
M$1508 VGND dac_out[13] \$I427 VGND sg13_lv_nmos L=0.13u W=0.15u AS=0.1005p
+ AD=0.1005p PS=1.34u PD=1.34u rfmode=0
M$1509 VGND \$I425 \$I424 VGND sg13_lv_nmos L=0.13u W=0.15u AS=0.1005p
+ AD=0.1005p PS=1.34u PD=1.34u rfmode=0
M$1510 VGND \$I432 \$I430 VGND sg13_lv_nmos L=0.13u W=0.15u AS=0.1005p
+ AD=0.1005p PS=1.34u PD=1.34u rfmode=0
M$1511 VGND dac_out[9] \$I432 VGND sg13_lv_nmos L=0.13u W=0.15u AS=0.1005p
+ AD=0.1005p PS=1.34u PD=1.34u rfmode=0
M$1512 VGND \$I430 \$I429 VGND sg13_lv_nmos L=0.13u W=0.15u AS=0.1005p
+ AD=0.1005p PS=1.34u PD=1.34u rfmode=0
M$1513 VGND \$I437 \$I435 VGND sg13_lv_nmos L=0.13u W=0.15u AS=0.1005p
+ AD=0.1005p PS=1.34u PD=1.34u rfmode=0
M$1514 VGND dac_out[15] \$I437 VGND sg13_lv_nmos L=0.13u W=0.15u AS=0.1005p
+ AD=0.1005p PS=1.34u PD=1.34u rfmode=0
M$1515 VGND \$I435 \$I434 VGND sg13_lv_nmos L=0.13u W=0.15u AS=0.1005p
+ AD=0.1005p PS=1.34u PD=1.34u rfmode=0
M$1516 VGND \$I442 \$I440 VGND sg13_lv_nmos L=0.13u W=0.15u AS=0.1005p
+ AD=0.1005p PS=1.34u PD=1.34u rfmode=0
M$1517 VGND \$I20 \$I442 VGND sg13_lv_nmos L=0.13u W=0.15u AS=0.1005p
+ AD=0.1005p PS=1.34u PD=1.34u rfmode=0
M$1518 VGND \$I440 \$I439 VGND sg13_lv_nmos L=0.13u W=0.15u AS=0.1005p
+ AD=0.1005p PS=1.34u PD=1.34u rfmode=0
M$1519 VGND \$I447 \$I445 VGND sg13_lv_nmos L=0.13u W=0.15u AS=0.1005p
+ AD=0.1005p PS=1.34u PD=1.34u rfmode=0
M$1520 VGND \$I29 \$I447 VGND sg13_lv_nmos L=0.13u W=0.15u AS=0.1005p
+ AD=0.1005p PS=1.34u PD=1.34u rfmode=0
M$1521 VGND \$I445 \$I444 VGND sg13_lv_nmos L=0.13u W=0.15u AS=0.1005p
+ AD=0.1005p PS=1.34u PD=1.34u rfmode=0
M$1522 VGND \$I452 \$I450 VGND sg13_lv_nmos L=0.13u W=0.15u AS=0.1005p
+ AD=0.1005p PS=1.34u PD=1.34u rfmode=0
M$1523 VGND \$I23 \$I452 VGND sg13_lv_nmos L=0.13u W=0.15u AS=0.1005p
+ AD=0.1005p PS=1.34u PD=1.34u rfmode=0
M$1524 VGND \$I450 \$I449 VGND sg13_lv_nmos L=0.13u W=0.15u AS=0.1005p
+ AD=0.1005p PS=1.34u PD=1.34u rfmode=0
M$1525 VGND \$I457 \$I455 VGND sg13_lv_nmos L=0.13u W=0.15u AS=0.1005p
+ AD=0.1005p PS=1.34u PD=1.34u rfmode=0
M$1526 VGND \$I17 \$I457 VGND sg13_lv_nmos L=0.13u W=0.15u AS=0.1005p
+ AD=0.1005p PS=1.34u PD=1.34u rfmode=0
M$1527 VGND \$I455 \$I454 VGND sg13_lv_nmos L=0.13u W=0.15u AS=0.1005p
+ AD=0.1005p PS=1.34u PD=1.34u rfmode=0
M$1528 VGND \$I462 \$I460 VGND sg13_lv_nmos L=0.13u W=0.15u AS=0.1005p
+ AD=0.1005p PS=1.34u PD=1.34u rfmode=0
M$1529 VGND \$I11 \$I462 VGND sg13_lv_nmos L=0.13u W=0.15u AS=0.1005p
+ AD=0.1005p PS=1.34u PD=1.34u rfmode=0
M$1530 VGND \$I460 \$I459 VGND sg13_lv_nmos L=0.13u W=0.15u AS=0.1005p
+ AD=0.1005p PS=1.34u PD=1.34u rfmode=0
M$1531 VGND \$I467 \$I465 VGND sg13_lv_nmos L=0.13u W=0.15u AS=0.1005p
+ AD=0.1005p PS=1.34u PD=1.34u rfmode=0
M$1532 VGND \$I26 \$I467 VGND sg13_lv_nmos L=0.13u W=0.15u AS=0.1005p
+ AD=0.1005p PS=1.34u PD=1.34u rfmode=0
M$1533 VGND \$I465 \$I464 VGND sg13_lv_nmos L=0.13u W=0.15u AS=0.1005p
+ AD=0.1005p PS=1.34u PD=1.34u rfmode=0
M$1534 VGND \$I472 \$I470 VGND sg13_lv_nmos L=0.13u W=0.15u AS=0.1005p
+ AD=0.1005p PS=1.34u PD=1.34u rfmode=0
M$1535 VGND \$I14 \$I472 VGND sg13_lv_nmos L=0.13u W=0.15u AS=0.1005p
+ AD=0.1005p PS=1.34u PD=1.34u rfmode=0
M$1536 VGND \$I470 \$I469 VGND sg13_lv_nmos L=0.13u W=0.15u AS=0.1005p
+ AD=0.1005p PS=1.34u PD=1.34u rfmode=0
M$1537 VGND \$I477 \$I475 VGND sg13_lv_nmos L=0.13u W=0.15u AS=0.1005p
+ AD=0.1005p PS=1.34u PD=1.34u rfmode=0
M$1538 VGND \$I32 \$I477 VGND sg13_lv_nmos L=0.13u W=0.15u AS=0.1005p
+ AD=0.1005p PS=1.34u PD=1.34u rfmode=0
M$1539 VGND \$I475 \$I474 VGND sg13_lv_nmos L=0.13u W=0.15u AS=0.1005p
+ AD=0.1005p PS=1.34u PD=1.34u rfmode=0
M$1540 VGND \$I482 \$I480 VGND sg13_lv_nmos L=0.13u W=0.15u AS=0.1005p
+ AD=0.1005p PS=1.34u PD=1.34u rfmode=0
M$1541 VGND dac_out[3] \$I482 VGND sg13_lv_nmos L=0.13u W=0.15u AS=0.1005p
+ AD=0.1005p PS=1.34u PD=1.34u rfmode=0
M$1542 VGND \$I480 \$I479 VGND sg13_lv_nmos L=0.13u W=0.15u AS=0.1005p
+ AD=0.1005p PS=1.34u PD=1.34u rfmode=0
M$1543 VGND \$I487 \$I485 VGND sg13_lv_nmos L=0.13u W=0.15u AS=0.1005p
+ AD=0.1005p PS=1.34u PD=1.34u rfmode=0
M$1544 VGND dac_out[6] \$I487 VGND sg13_lv_nmos L=0.13u W=0.15u AS=0.1005p
+ AD=0.1005p PS=1.34u PD=1.34u rfmode=0
M$1545 VGND \$I485 \$I484 VGND sg13_lv_nmos L=0.13u W=0.15u AS=0.1005p
+ AD=0.1005p PS=1.34u PD=1.34u rfmode=0
M$1546 VGND \$I492 \$I490 VGND sg13_lv_nmos L=0.13u W=0.15u AS=0.1005p
+ AD=0.1005p PS=1.34u PD=1.34u rfmode=0
M$1547 VGND dac_out[4] \$I492 VGND sg13_lv_nmos L=0.13u W=0.15u AS=0.1005p
+ AD=0.1005p PS=1.34u PD=1.34u rfmode=0
M$1548 VGND \$I490 \$I489 VGND sg13_lv_nmos L=0.13u W=0.15u AS=0.1005p
+ AD=0.1005p PS=1.34u PD=1.34u rfmode=0
M$1549 VGND \$I497 \$I495 VGND sg13_lv_nmos L=0.13u W=0.15u AS=0.1005p
+ AD=0.1005p PS=1.34u PD=1.34u rfmode=0
M$1550 VGND dac_out[2] \$I497 VGND sg13_lv_nmos L=0.13u W=0.15u AS=0.1005p
+ AD=0.1005p PS=1.34u PD=1.34u rfmode=0
M$1551 VGND \$I495 \$I494 VGND sg13_lv_nmos L=0.13u W=0.15u AS=0.1005p
+ AD=0.1005p PS=1.34u PD=1.34u rfmode=0
M$1552 VGND \$I502 \$I500 VGND sg13_lv_nmos L=0.13u W=0.15u AS=0.1005p
+ AD=0.1005p PS=1.34u PD=1.34u rfmode=0
M$1553 VGND dac_out[0] \$I502 VGND sg13_lv_nmos L=0.13u W=0.15u AS=0.1005p
+ AD=0.1005p PS=1.34u PD=1.34u rfmode=0
M$1554 VGND \$I500 \$I499 VGND sg13_lv_nmos L=0.13u W=0.15u AS=0.1005p
+ AD=0.1005p PS=1.34u PD=1.34u rfmode=0
M$1555 VGND \$I507 \$I505 VGND sg13_lv_nmos L=0.13u W=0.15u AS=0.1005p
+ AD=0.1005p PS=1.34u PD=1.34u rfmode=0
M$1556 VGND dac_out[5] \$I507 VGND sg13_lv_nmos L=0.13u W=0.15u AS=0.1005p
+ AD=0.1005p PS=1.34u PD=1.34u rfmode=0
M$1557 VGND \$I505 \$I504 VGND sg13_lv_nmos L=0.13u W=0.15u AS=0.1005p
+ AD=0.1005p PS=1.34u PD=1.34u rfmode=0
M$1558 VGND \$I512 \$I510 VGND sg13_lv_nmos L=0.13u W=0.15u AS=0.1005p
+ AD=0.1005p PS=1.34u PD=1.34u rfmode=0
M$1559 VGND dac_out[1] \$I512 VGND sg13_lv_nmos L=0.13u W=0.15u AS=0.1005p
+ AD=0.1005p PS=1.34u PD=1.34u rfmode=0
M$1560 VGND \$I510 \$I509 VGND sg13_lv_nmos L=0.13u W=0.15u AS=0.1005p
+ AD=0.1005p PS=1.34u PD=1.34u rfmode=0
M$1561 VGND \$I517 \$I515 VGND sg13_lv_nmos L=0.13u W=0.15u AS=0.1005p
+ AD=0.1005p PS=1.34u PD=1.34u rfmode=0
M$1562 VGND dac_out[7] \$I517 VGND sg13_lv_nmos L=0.13u W=0.15u AS=0.1005p
+ AD=0.1005p PS=1.34u PD=1.34u rfmode=0
M$1563 VGND \$I515 \$I514 VGND sg13_lv_nmos L=0.13u W=0.15u AS=0.1005p
+ AD=0.1005p PS=1.34u PD=1.34u rfmode=0
M$1564 VGND \$I398 \$I45 VGND sg13_hv_nmos L=0.45u W=1.2u AS=0.408p AD=0.408p
+ PS=5.12u PD=5.12u rfmode=0
M$1568 VGND \$I403 \$I54 VGND sg13_hv_nmos L=0.45u W=1.2u AS=0.408p AD=0.408p
+ PS=5.12u PD=5.12u rfmode=0
M$1572 VGND \$I408 \$I48 VGND sg13_hv_nmos L=0.45u W=1.2u AS=0.408p AD=0.408p
+ PS=5.12u PD=5.12u rfmode=0
M$1576 VGND \$I413 \$I42 VGND sg13_hv_nmos L=0.45u W=1.2u AS=0.408p AD=0.408p
+ PS=5.12u PD=5.12u rfmode=0
M$1580 VGND \$I418 \$I36 VGND sg13_hv_nmos L=0.45u W=1.2u AS=0.408p AD=0.408p
+ PS=5.12u PD=5.12u rfmode=0
M$1584 VGND \$I423 \$I51 VGND sg13_hv_nmos L=0.45u W=1.2u AS=0.408p AD=0.408p
+ PS=5.12u PD=5.12u rfmode=0
M$1588 VGND \$I428 \$I39 VGND sg13_hv_nmos L=0.45u W=1.2u AS=0.408p AD=0.408p
+ PS=5.12u PD=5.12u rfmode=0
M$1592 VGND \$I433 \$I57 VGND sg13_hv_nmos L=0.45u W=1.2u AS=0.408p AD=0.408p
+ PS=5.12u PD=5.12u rfmode=0
M$1596 VGND \$I438 \$I44 VGND sg13_hv_nmos L=0.45u W=1.2u AS=0.408p AD=0.408p
+ PS=5.12u PD=5.12u rfmode=0
M$1600 VGND \$I443 \$I53 VGND sg13_hv_nmos L=0.45u W=1.2u AS=0.408p AD=0.408p
+ PS=5.12u PD=5.12u rfmode=0
M$1604 VGND \$I448 \$I47 VGND sg13_hv_nmos L=0.45u W=1.2u AS=0.408p AD=0.408p
+ PS=5.12u PD=5.12u rfmode=0
M$1608 VGND \$I453 \$I41 VGND sg13_hv_nmos L=0.45u W=1.2u AS=0.408p AD=0.408p
+ PS=5.12u PD=5.12u rfmode=0
M$1612 VGND \$I458 \$I35 VGND sg13_hv_nmos L=0.45u W=1.2u AS=0.408p AD=0.408p
+ PS=5.12u PD=5.12u rfmode=0
M$1616 VGND \$I463 \$I50 VGND sg13_hv_nmos L=0.45u W=1.2u AS=0.408p AD=0.408p
+ PS=5.12u PD=5.12u rfmode=0
M$1620 VGND \$I468 \$I38 VGND sg13_hv_nmos L=0.45u W=1.2u AS=0.408p AD=0.408p
+ PS=5.12u PD=5.12u rfmode=0
M$1624 VGND \$I473 \$I56 VGND sg13_hv_nmos L=0.45u W=1.2u AS=0.408p AD=0.408p
+ PS=5.12u PD=5.12u rfmode=0
M$1628 VGND \$I478 \$I80 VGND sg13_hv_nmos L=0.45u W=1.2u AS=0.408p AD=0.408p
+ PS=5.12u PD=5.12u rfmode=0
M$1632 VGND \$I483 \$I86 VGND sg13_hv_nmos L=0.45u W=1.2u AS=0.408p AD=0.408p
+ PS=5.12u PD=5.12u rfmode=0
M$1636 VGND \$I488 \$I82 VGND sg13_hv_nmos L=0.45u W=1.2u AS=0.408p AD=0.408p
+ PS=5.12u PD=5.12u rfmode=0
M$1640 VGND \$I493 \$I78 VGND sg13_hv_nmos L=0.45u W=1.2u AS=0.408p AD=0.408p
+ PS=5.12u PD=5.12u rfmode=0
M$1644 VGND \$I498 \$I74 VGND sg13_hv_nmos L=0.45u W=1.2u AS=0.408p AD=0.408p
+ PS=5.12u PD=5.12u rfmode=0
M$1648 VGND \$I503 \$I84 VGND sg13_hv_nmos L=0.45u W=1.2u AS=0.408p AD=0.408p
+ PS=5.12u PD=5.12u rfmode=0
M$1652 VGND \$I508 \$I76 VGND sg13_hv_nmos L=0.45u W=1.2u AS=0.408p AD=0.408p
+ PS=5.12u PD=5.12u rfmode=0
M$1656 VGND \$I513 \$I88 VGND sg13_hv_nmos L=0.45u W=1.2u AS=0.408p AD=0.408p
+ PS=5.12u PD=5.12u rfmode=0
M$1660 \$I45 \$I398 VAPWR VAPWR sg13_hv_pmos L=0.45u W=2.4u AS=0.816p AD=0.816p
+ PS=7.52u PD=7.52u rfmode=0
M$1664 \$I54 \$I403 VAPWR VAPWR sg13_hv_pmos L=0.45u W=2.4u AS=0.816p AD=0.816p
+ PS=7.52u PD=7.52u rfmode=0
M$1668 \$I48 \$I408 VAPWR VAPWR sg13_hv_pmos L=0.45u W=2.4u AS=0.816p AD=0.816p
+ PS=7.52u PD=7.52u rfmode=0
M$1672 \$I42 \$I413 VAPWR VAPWR sg13_hv_pmos L=0.45u W=2.4u AS=0.816p AD=0.816p
+ PS=7.52u PD=7.52u rfmode=0
M$1676 \$I36 \$I418 VAPWR VAPWR sg13_hv_pmos L=0.45u W=2.4u AS=0.816p AD=0.816p
+ PS=7.52u PD=7.52u rfmode=0
M$1680 \$I51 \$I423 VAPWR VAPWR sg13_hv_pmos L=0.45u W=2.4u AS=0.816p AD=0.816p
+ PS=7.52u PD=7.52u rfmode=0
M$1684 \$I39 \$I428 VAPWR VAPWR sg13_hv_pmos L=0.45u W=2.4u AS=0.816p AD=0.816p
+ PS=7.52u PD=7.52u rfmode=0
M$1688 \$I57 \$I433 VAPWR VAPWR sg13_hv_pmos L=0.45u W=2.4u AS=0.816p AD=0.816p
+ PS=7.52u PD=7.52u rfmode=0
M$1692 \$I44 \$I438 VAPWR VAPWR sg13_hv_pmos L=0.45u W=2.4u AS=0.816p AD=0.816p
+ PS=7.52u PD=7.52u rfmode=0
M$1696 \$I53 \$I443 VAPWR VAPWR sg13_hv_pmos L=0.45u W=2.4u AS=0.816p AD=0.816p
+ PS=7.52u PD=7.52u rfmode=0
M$1700 \$I47 \$I448 VAPWR VAPWR sg13_hv_pmos L=0.45u W=2.4u AS=0.816p AD=0.816p
+ PS=7.52u PD=7.52u rfmode=0
M$1704 \$I41 \$I453 VAPWR VAPWR sg13_hv_pmos L=0.45u W=2.4u AS=0.816p AD=0.816p
+ PS=7.52u PD=7.52u rfmode=0
M$1708 \$I35 \$I458 VAPWR VAPWR sg13_hv_pmos L=0.45u W=2.4u AS=0.816p AD=0.816p
+ PS=7.52u PD=7.52u rfmode=0
M$1712 \$I50 \$I463 VAPWR VAPWR sg13_hv_pmos L=0.45u W=2.4u AS=0.816p AD=0.816p
+ PS=7.52u PD=7.52u rfmode=0
M$1716 \$I38 \$I468 VAPWR VAPWR sg13_hv_pmos L=0.45u W=2.4u AS=0.816p AD=0.816p
+ PS=7.52u PD=7.52u rfmode=0
M$1720 \$I56 \$I473 VAPWR VAPWR sg13_hv_pmos L=0.45u W=2.4u AS=0.816p AD=0.816p
+ PS=7.52u PD=7.52u rfmode=0
M$1724 \$I80 \$I478 VAPWR VAPWR sg13_hv_pmos L=0.45u W=2.4u AS=0.816p AD=0.816p
+ PS=7.52u PD=7.52u rfmode=0
M$1728 \$I86 \$I483 VAPWR VAPWR sg13_hv_pmos L=0.45u W=2.4u AS=0.816p AD=0.816p
+ PS=7.52u PD=7.52u rfmode=0
M$1732 \$I82 \$I488 VAPWR VAPWR sg13_hv_pmos L=0.45u W=2.4u AS=0.816p AD=0.816p
+ PS=7.52u PD=7.52u rfmode=0
M$1736 \$I78 \$I493 VAPWR VAPWR sg13_hv_pmos L=0.45u W=2.4u AS=0.816p AD=0.816p
+ PS=7.52u PD=7.52u rfmode=0
M$1740 \$I74 \$I498 VAPWR VAPWR sg13_hv_pmos L=0.45u W=2.4u AS=0.816p AD=0.816p
+ PS=7.52u PD=7.52u rfmode=0
M$1744 \$I84 \$I503 VAPWR VAPWR sg13_hv_pmos L=0.45u W=2.4u AS=0.816p AD=0.816p
+ PS=7.52u PD=7.52u rfmode=0
M$1748 \$I76 \$I508 VAPWR VAPWR sg13_hv_pmos L=0.45u W=2.4u AS=0.816p AD=0.816p
+ PS=7.52u PD=7.52u rfmode=0
M$1752 \$I88 \$I513 VAPWR VAPWR sg13_hv_pmos L=0.45u W=2.4u AS=0.816p AD=0.816p
+ PS=7.52u PD=7.52u rfmode=0
M$1756 \$I401 \$I398 VAPWR VAPWR sg13_hv_pmos L=0.45u W=0.3u AS=0.102p
+ AD=0.102p PS=1.28u PD=1.28u rfmode=0
M$1757 \$I398 \$I401 VAPWR VAPWR sg13_hv_pmos L=0.45u W=0.3u AS=0.102p
+ AD=0.102p PS=1.28u PD=1.28u rfmode=0
M$1758 \$I406 \$I403 VAPWR VAPWR sg13_hv_pmos L=0.45u W=0.3u AS=0.102p
+ AD=0.102p PS=1.28u PD=1.28u rfmode=0
M$1759 \$I403 \$I406 VAPWR VAPWR sg13_hv_pmos L=0.45u W=0.3u AS=0.102p
+ AD=0.102p PS=1.28u PD=1.28u rfmode=0
M$1760 \$I411 \$I408 VAPWR VAPWR sg13_hv_pmos L=0.45u W=0.3u AS=0.102p
+ AD=0.102p PS=1.28u PD=1.28u rfmode=0
M$1761 \$I408 \$I411 VAPWR VAPWR sg13_hv_pmos L=0.45u W=0.3u AS=0.102p
+ AD=0.102p PS=1.28u PD=1.28u rfmode=0
M$1762 \$I416 \$I413 VAPWR VAPWR sg13_hv_pmos L=0.45u W=0.3u AS=0.102p
+ AD=0.102p PS=1.28u PD=1.28u rfmode=0
M$1763 \$I413 \$I416 VAPWR VAPWR sg13_hv_pmos L=0.45u W=0.3u AS=0.102p
+ AD=0.102p PS=1.28u PD=1.28u rfmode=0
M$1764 \$I421 \$I418 VAPWR VAPWR sg13_hv_pmos L=0.45u W=0.3u AS=0.102p
+ AD=0.102p PS=1.28u PD=1.28u rfmode=0
M$1765 \$I418 \$I421 VAPWR VAPWR sg13_hv_pmos L=0.45u W=0.3u AS=0.102p
+ AD=0.102p PS=1.28u PD=1.28u rfmode=0
M$1766 \$I426 \$I423 VAPWR VAPWR sg13_hv_pmos L=0.45u W=0.3u AS=0.102p
+ AD=0.102p PS=1.28u PD=1.28u rfmode=0
M$1767 \$I423 \$I426 VAPWR VAPWR sg13_hv_pmos L=0.45u W=0.3u AS=0.102p
+ AD=0.102p PS=1.28u PD=1.28u rfmode=0
M$1768 \$I431 \$I428 VAPWR VAPWR sg13_hv_pmos L=0.45u W=0.3u AS=0.102p
+ AD=0.102p PS=1.28u PD=1.28u rfmode=0
M$1769 \$I428 \$I431 VAPWR VAPWR sg13_hv_pmos L=0.45u W=0.3u AS=0.102p
+ AD=0.102p PS=1.28u PD=1.28u rfmode=0
M$1770 \$I436 \$I433 VAPWR VAPWR sg13_hv_pmos L=0.45u W=0.3u AS=0.102p
+ AD=0.102p PS=1.28u PD=1.28u rfmode=0
M$1771 \$I433 \$I436 VAPWR VAPWR sg13_hv_pmos L=0.45u W=0.3u AS=0.102p
+ AD=0.102p PS=1.28u PD=1.28u rfmode=0
M$1772 \$I441 \$I438 VAPWR VAPWR sg13_hv_pmos L=0.45u W=0.3u AS=0.102p
+ AD=0.102p PS=1.28u PD=1.28u rfmode=0
M$1773 \$I438 \$I441 VAPWR VAPWR sg13_hv_pmos L=0.45u W=0.3u AS=0.102p
+ AD=0.102p PS=1.28u PD=1.28u rfmode=0
M$1774 \$I446 \$I443 VAPWR VAPWR sg13_hv_pmos L=0.45u W=0.3u AS=0.102p
+ AD=0.102p PS=1.28u PD=1.28u rfmode=0
M$1775 \$I443 \$I446 VAPWR VAPWR sg13_hv_pmos L=0.45u W=0.3u AS=0.102p
+ AD=0.102p PS=1.28u PD=1.28u rfmode=0
M$1776 \$I451 \$I448 VAPWR VAPWR sg13_hv_pmos L=0.45u W=0.3u AS=0.102p
+ AD=0.102p PS=1.28u PD=1.28u rfmode=0
M$1777 \$I448 \$I451 VAPWR VAPWR sg13_hv_pmos L=0.45u W=0.3u AS=0.102p
+ AD=0.102p PS=1.28u PD=1.28u rfmode=0
M$1778 \$I456 \$I453 VAPWR VAPWR sg13_hv_pmos L=0.45u W=0.3u AS=0.102p
+ AD=0.102p PS=1.28u PD=1.28u rfmode=0
M$1779 \$I453 \$I456 VAPWR VAPWR sg13_hv_pmos L=0.45u W=0.3u AS=0.102p
+ AD=0.102p PS=1.28u PD=1.28u rfmode=0
M$1780 \$I461 \$I458 VAPWR VAPWR sg13_hv_pmos L=0.45u W=0.3u AS=0.102p
+ AD=0.102p PS=1.28u PD=1.28u rfmode=0
M$1781 \$I458 \$I461 VAPWR VAPWR sg13_hv_pmos L=0.45u W=0.3u AS=0.102p
+ AD=0.102p PS=1.28u PD=1.28u rfmode=0
M$1782 \$I466 \$I463 VAPWR VAPWR sg13_hv_pmos L=0.45u W=0.3u AS=0.102p
+ AD=0.102p PS=1.28u PD=1.28u rfmode=0
M$1783 \$I463 \$I466 VAPWR VAPWR sg13_hv_pmos L=0.45u W=0.3u AS=0.102p
+ AD=0.102p PS=1.28u PD=1.28u rfmode=0
M$1784 \$I471 \$I468 VAPWR VAPWR sg13_hv_pmos L=0.45u W=0.3u AS=0.102p
+ AD=0.102p PS=1.28u PD=1.28u rfmode=0
M$1785 \$I468 \$I471 VAPWR VAPWR sg13_hv_pmos L=0.45u W=0.3u AS=0.102p
+ AD=0.102p PS=1.28u PD=1.28u rfmode=0
M$1786 \$I476 \$I473 VAPWR VAPWR sg13_hv_pmos L=0.45u W=0.3u AS=0.102p
+ AD=0.102p PS=1.28u PD=1.28u rfmode=0
M$1787 \$I473 \$I476 VAPWR VAPWR sg13_hv_pmos L=0.45u W=0.3u AS=0.102p
+ AD=0.102p PS=1.28u PD=1.28u rfmode=0
M$1788 \$I481 \$I478 VAPWR VAPWR sg13_hv_pmos L=0.45u W=0.3u AS=0.102p
+ AD=0.102p PS=1.28u PD=1.28u rfmode=0
M$1789 \$I478 \$I481 VAPWR VAPWR sg13_hv_pmos L=0.45u W=0.3u AS=0.102p
+ AD=0.102p PS=1.28u PD=1.28u rfmode=0
M$1790 \$I486 \$I483 VAPWR VAPWR sg13_hv_pmos L=0.45u W=0.3u AS=0.102p
+ AD=0.102p PS=1.28u PD=1.28u rfmode=0
M$1791 \$I483 \$I486 VAPWR VAPWR sg13_hv_pmos L=0.45u W=0.3u AS=0.102p
+ AD=0.102p PS=1.28u PD=1.28u rfmode=0
M$1792 \$I491 \$I488 VAPWR VAPWR sg13_hv_pmos L=0.45u W=0.3u AS=0.102p
+ AD=0.102p PS=1.28u PD=1.28u rfmode=0
M$1793 \$I488 \$I491 VAPWR VAPWR sg13_hv_pmos L=0.45u W=0.3u AS=0.102p
+ AD=0.102p PS=1.28u PD=1.28u rfmode=0
M$1794 \$I496 \$I493 VAPWR VAPWR sg13_hv_pmos L=0.45u W=0.3u AS=0.102p
+ AD=0.102p PS=1.28u PD=1.28u rfmode=0
M$1795 \$I493 \$I496 VAPWR VAPWR sg13_hv_pmos L=0.45u W=0.3u AS=0.102p
+ AD=0.102p PS=1.28u PD=1.28u rfmode=0
M$1796 \$I501 \$I498 VAPWR VAPWR sg13_hv_pmos L=0.45u W=0.3u AS=0.102p
+ AD=0.102p PS=1.28u PD=1.28u rfmode=0
M$1797 \$I498 \$I501 VAPWR VAPWR sg13_hv_pmos L=0.45u W=0.3u AS=0.102p
+ AD=0.102p PS=1.28u PD=1.28u rfmode=0
M$1798 \$I506 \$I503 VAPWR VAPWR sg13_hv_pmos L=0.45u W=0.3u AS=0.102p
+ AD=0.102p PS=1.28u PD=1.28u rfmode=0
M$1799 \$I503 \$I506 VAPWR VAPWR sg13_hv_pmos L=0.45u W=0.3u AS=0.102p
+ AD=0.102p PS=1.28u PD=1.28u rfmode=0
M$1800 \$I511 \$I508 VAPWR VAPWR sg13_hv_pmos L=0.45u W=0.3u AS=0.102p
+ AD=0.102p PS=1.28u PD=1.28u rfmode=0
M$1801 \$I508 \$I511 VAPWR VAPWR sg13_hv_pmos L=0.45u W=0.3u AS=0.102p
+ AD=0.102p PS=1.28u PD=1.28u rfmode=0
M$1802 \$I516 \$I513 VAPWR VAPWR sg13_hv_pmos L=0.45u W=0.3u AS=0.102p
+ AD=0.102p PS=1.28u PD=1.28u rfmode=0
M$1803 \$I513 \$I516 VAPWR VAPWR sg13_hv_pmos L=0.45u W=0.3u AS=0.102p
+ AD=0.102p PS=1.28u PD=1.28u rfmode=0
M$1804 VGND \$I400 \$I401 VGND sg13_hv_nmos L=0.45u W=1u AS=0.34p AD=0.34p
+ PS=2.68u PD=2.68u rfmode=0
M$1805 VGND \$I399 \$I398 VGND sg13_hv_nmos L=0.45u W=1u AS=0.34p AD=0.34p
+ PS=2.68u PD=2.68u rfmode=0
M$1806 VGND \$I405 \$I406 VGND sg13_hv_nmos L=0.45u W=1u AS=0.34p AD=0.34p
+ PS=2.68u PD=2.68u rfmode=0
M$1807 VGND \$I404 \$I403 VGND sg13_hv_nmos L=0.45u W=1u AS=0.34p AD=0.34p
+ PS=2.68u PD=2.68u rfmode=0
M$1808 VGND \$I410 \$I411 VGND sg13_hv_nmos L=0.45u W=1u AS=0.34p AD=0.34p
+ PS=2.68u PD=2.68u rfmode=0
M$1809 VGND \$I409 \$I408 VGND sg13_hv_nmos L=0.45u W=1u AS=0.34p AD=0.34p
+ PS=2.68u PD=2.68u rfmode=0
M$1810 VGND \$I415 \$I416 VGND sg13_hv_nmos L=0.45u W=1u AS=0.34p AD=0.34p
+ PS=2.68u PD=2.68u rfmode=0
M$1811 VGND \$I414 \$I413 VGND sg13_hv_nmos L=0.45u W=1u AS=0.34p AD=0.34p
+ PS=2.68u PD=2.68u rfmode=0
M$1812 VGND \$I420 \$I421 VGND sg13_hv_nmos L=0.45u W=1u AS=0.34p AD=0.34p
+ PS=2.68u PD=2.68u rfmode=0
M$1813 VGND \$I419 \$I418 VGND sg13_hv_nmos L=0.45u W=1u AS=0.34p AD=0.34p
+ PS=2.68u PD=2.68u rfmode=0
M$1814 VGND \$I425 \$I426 VGND sg13_hv_nmos L=0.45u W=1u AS=0.34p AD=0.34p
+ PS=2.68u PD=2.68u rfmode=0
M$1815 VGND \$I424 \$I423 VGND sg13_hv_nmos L=0.45u W=1u AS=0.34p AD=0.34p
+ PS=2.68u PD=2.68u rfmode=0
M$1816 VGND \$I430 \$I431 VGND sg13_hv_nmos L=0.45u W=1u AS=0.34p AD=0.34p
+ PS=2.68u PD=2.68u rfmode=0
M$1817 VGND \$I429 \$I428 VGND sg13_hv_nmos L=0.45u W=1u AS=0.34p AD=0.34p
+ PS=2.68u PD=2.68u rfmode=0
M$1818 VGND \$I435 \$I436 VGND sg13_hv_nmos L=0.45u W=1u AS=0.34p AD=0.34p
+ PS=2.68u PD=2.68u rfmode=0
M$1819 VGND \$I434 \$I433 VGND sg13_hv_nmos L=0.45u W=1u AS=0.34p AD=0.34p
+ PS=2.68u PD=2.68u rfmode=0
M$1820 VGND \$I440 \$I441 VGND sg13_hv_nmos L=0.45u W=1u AS=0.34p AD=0.34p
+ PS=2.68u PD=2.68u rfmode=0
M$1821 VGND \$I439 \$I438 VGND sg13_hv_nmos L=0.45u W=1u AS=0.34p AD=0.34p
+ PS=2.68u PD=2.68u rfmode=0
M$1822 VGND \$I445 \$I446 VGND sg13_hv_nmos L=0.45u W=1u AS=0.34p AD=0.34p
+ PS=2.68u PD=2.68u rfmode=0
M$1823 VGND \$I444 \$I443 VGND sg13_hv_nmos L=0.45u W=1u AS=0.34p AD=0.34p
+ PS=2.68u PD=2.68u rfmode=0
M$1824 VGND \$I450 \$I451 VGND sg13_hv_nmos L=0.45u W=1u AS=0.34p AD=0.34p
+ PS=2.68u PD=2.68u rfmode=0
M$1825 VGND \$I449 \$I448 VGND sg13_hv_nmos L=0.45u W=1u AS=0.34p AD=0.34p
+ PS=2.68u PD=2.68u rfmode=0
M$1826 VGND \$I455 \$I456 VGND sg13_hv_nmos L=0.45u W=1u AS=0.34p AD=0.34p
+ PS=2.68u PD=2.68u rfmode=0
M$1827 VGND \$I454 \$I453 VGND sg13_hv_nmos L=0.45u W=1u AS=0.34p AD=0.34p
+ PS=2.68u PD=2.68u rfmode=0
M$1828 VGND \$I460 \$I461 VGND sg13_hv_nmos L=0.45u W=1u AS=0.34p AD=0.34p
+ PS=2.68u PD=2.68u rfmode=0
M$1829 VGND \$I459 \$I458 VGND sg13_hv_nmos L=0.45u W=1u AS=0.34p AD=0.34p
+ PS=2.68u PD=2.68u rfmode=0
M$1830 VGND \$I465 \$I466 VGND sg13_hv_nmos L=0.45u W=1u AS=0.34p AD=0.34p
+ PS=2.68u PD=2.68u rfmode=0
M$1831 VGND \$I464 \$I463 VGND sg13_hv_nmos L=0.45u W=1u AS=0.34p AD=0.34p
+ PS=2.68u PD=2.68u rfmode=0
M$1832 VGND \$I470 \$I471 VGND sg13_hv_nmos L=0.45u W=1u AS=0.34p AD=0.34p
+ PS=2.68u PD=2.68u rfmode=0
M$1833 VGND \$I469 \$I468 VGND sg13_hv_nmos L=0.45u W=1u AS=0.34p AD=0.34p
+ PS=2.68u PD=2.68u rfmode=0
M$1834 VGND \$I475 \$I476 VGND sg13_hv_nmos L=0.45u W=1u AS=0.34p AD=0.34p
+ PS=2.68u PD=2.68u rfmode=0
M$1835 VGND \$I474 \$I473 VGND sg13_hv_nmos L=0.45u W=1u AS=0.34p AD=0.34p
+ PS=2.68u PD=2.68u rfmode=0
M$1836 VGND \$I480 \$I481 VGND sg13_hv_nmos L=0.45u W=1u AS=0.34p AD=0.34p
+ PS=2.68u PD=2.68u rfmode=0
M$1837 VGND \$I479 \$I478 VGND sg13_hv_nmos L=0.45u W=1u AS=0.34p AD=0.34p
+ PS=2.68u PD=2.68u rfmode=0
M$1838 VGND \$I485 \$I486 VGND sg13_hv_nmos L=0.45u W=1u AS=0.34p AD=0.34p
+ PS=2.68u PD=2.68u rfmode=0
M$1839 VGND \$I484 \$I483 VGND sg13_hv_nmos L=0.45u W=1u AS=0.34p AD=0.34p
+ PS=2.68u PD=2.68u rfmode=0
M$1840 VGND \$I490 \$I491 VGND sg13_hv_nmos L=0.45u W=1u AS=0.34p AD=0.34p
+ PS=2.68u PD=2.68u rfmode=0
M$1841 VGND \$I489 \$I488 VGND sg13_hv_nmos L=0.45u W=1u AS=0.34p AD=0.34p
+ PS=2.68u PD=2.68u rfmode=0
M$1842 VGND \$I495 \$I496 VGND sg13_hv_nmos L=0.45u W=1u AS=0.34p AD=0.34p
+ PS=2.68u PD=2.68u rfmode=0
M$1843 VGND \$I494 \$I493 VGND sg13_hv_nmos L=0.45u W=1u AS=0.34p AD=0.34p
+ PS=2.68u PD=2.68u rfmode=0
M$1844 VGND \$I500 \$I501 VGND sg13_hv_nmos L=0.45u W=1u AS=0.34p AD=0.34p
+ PS=2.68u PD=2.68u rfmode=0
M$1845 VGND \$I499 \$I498 VGND sg13_hv_nmos L=0.45u W=1u AS=0.34p AD=0.34p
+ PS=2.68u PD=2.68u rfmode=0
M$1846 VGND \$I505 \$I506 VGND sg13_hv_nmos L=0.45u W=1u AS=0.34p AD=0.34p
+ PS=2.68u PD=2.68u rfmode=0
M$1847 VGND \$I504 \$I503 VGND sg13_hv_nmos L=0.45u W=1u AS=0.34p AD=0.34p
+ PS=2.68u PD=2.68u rfmode=0
M$1848 VGND \$I510 \$I511 VGND sg13_hv_nmos L=0.45u W=1u AS=0.34p AD=0.34p
+ PS=2.68u PD=2.68u rfmode=0
M$1849 VGND \$I509 \$I508 VGND sg13_hv_nmos L=0.45u W=1u AS=0.34p AD=0.34p
+ PS=2.68u PD=2.68u rfmode=0
M$1850 VGND \$I515 \$I516 VGND sg13_hv_nmos L=0.45u W=1u AS=0.34p AD=0.34p
+ PS=2.68u PD=2.68u rfmode=0
M$1851 VGND \$I514 \$I513 VGND sg13_hv_nmos L=0.45u W=1u AS=0.34p AD=0.34p
+ PS=2.68u PD=2.68u rfmode=0
.ENDS analogue_interface
