* PEX produced on Thu Oct  8 16:47:05 CEST 2026 using scripts/sak-pex.sh with m=3 and s=1 (extresist threshold=10000 mOhm, minres=1000 mOhm, mindelay=1 ps)
* NGSPICE file created from r2r_dac_pex.ext - technology: ihp-sg13cmos5l

.subckt r2r_dac_pex IDACIREF nD0 nD1 nD2 nD3 nD4 nD5 nD6 nD7
X0 PDACVDD.t75 a_10714_5055# a_14228_5819# PDACVDD.t0 sg13_hv_pmos ad=0.408p pd=3.08u as=0.228p ps=1.58u w=1.2u l=1.2u
X1 a_12980_5491.t12 a_8700_4135# a_12463_2551# PDACVDD.t0 sg13_hv_pmos ad=0.408p pd=3.08u as=0.228p ps=1.58u w=1.2u l=0.6u
X2 PDACVDD.t121 a_12980_5491.t22 ODACOUT.t5 PDACVDD.t0 sg13_hv_pmos ad=0.816p pd=5.48u as=0.816p ps=5.48u w=2.4u l=0.4u
X3 ODACOUT.t52 a_13474_923.t23 PDACVSS.t231 PDACVSS.t223 sg13_hv_nmos ad=0.408p pd=3.08u as=0.408p ps=3.08u w=1.2u l=0.6u
X4 a_12306_727# a_11732_5491# PDACVSS.t184 PDACVSS.t35 sg13_hv_nmos ad=0.114p pd=0.98u as=0.204p ps=1.88u w=0.6u l=2.4u
X5 a_2050_3288# a_1786_3288# PDACVSS.t1 rhigh l=15u w=0.5u
X6 a_12463_2551# IDACVTAP a_10846_923# PDACVSS.t15 sg13_hv_nmos ad=0.816p pd=5.48u as=0.816p ps=5.48u w=2.4u l=0.45u
X7 PDACVSS.t106 PDACVSS.t100 PDACVSS.t105 PDACVSS.t104 sg13_hv_nmos ad=0.408p pd=3.08u as=0 ps=0 w=1.2u l=0.6u
X8 PDACVSS.t138 PDACVSS.t136 PDACVSS.t137 PDACVSS.t101 sg13_hv_nmos ad=0.408p pd=3.08u as=0 ps=0 w=1.2u l=0.6u
X9 PDACVDD.t65 a_10714_5055# a_11732_5295# PDACVDD.t0 sg13_hv_pmos ad=0.408p pd=3.08u as=0.228p ps=1.58u w=1.2u l=1.2u
X10 PDACVSS.t93 PDACVSS.t91 PDACVSS.t92 PDACVSS.t14 sg13_hv_nmos ad=0.816p pd=5.48u as=0 ps=0 w=2.4u l=0.45u
X11 a_11732_5491# a_8780_247# a_12306_727# PDACVSS.t35 sg13_hv_nmos ad=0.204p pd=1.88u as=0.114p ps=0.98u w=0.6u l=0.6u
X12 a_8968_2247# a_8780_247# PDACVSS.t23 PDACVSS.t22 sg13_hv_nmos ad=0.136p pd=1.48u as=0.136p ps=1.48u w=0.4u l=10u
X13 PDACVSS.t166 a_10180_247# a_10846_727# PDACVSS.t33 sg13_hv_nmos ad=0.204p pd=1.88u as=0.114p ps=0.98u w=0.6u l=2.4u
X14 a_13474_727# a_11732_5491# PDACVSS.t189 PDACVSS.t40 sg13_hv_nmos ad=0.114p pd=0.98u as=0.204p ps=1.88u w=0.6u l=2.4u
X15 PDACVDD.t2 a_10262_923# a_12014_923# PDACVDD.t0 sg13_hv_pmos ad=0.228p pd=1.58u as=0.408p ps=3.08u w=1.2u l=0.6u
X16 PDACVDD.t107 a_12980_5491.t24 ODACOUT.t23 PDACVDD.t0 sg13_hv_pmos ad=0.816p pd=5.48u as=0.816p ps=5.48u w=2.4u l=0.4u
X17 PDACVDD.t138 a_12980_5491.t18 ODACOUT.t15 PDACVDD.t0 sg13_hv_pmos ad=0.816p pd=5.48u as=0.816p ps=5.48u w=2.4u l=0.4u
X18 PDACVDD.t139 a_12980_5491.t18 ODACOUT.t20 PDACVDD.t0 sg13_hv_pmos ad=0.816p pd=5.48u as=0.816p ps=5.48u w=2.4u l=0.4u
X19 PDACVDD.t1 a_15859_6052# a_15859_6052# PDACVDD.t0 sg13_hv_pmos ad=0.816p pd=5.48u as=0.816p ps=5.48u w=2.4u l=0.4u
X20 ODACOUT.t27 a_12980_5491.t21 PDACVDD.t125 PDACVDD.t0 sg13_hv_pmos ad=0.816p pd=5.48u as=0.816p ps=5.48u w=2.4u l=0.4u
X21 a_13474_923.t9 a_8780_247# a_13474_727# PDACVSS.t40 sg13_hv_nmos ad=0.204p pd=1.88u as=0.114p ps=0.98u w=0.6u l=0.6u
X22 PDACVDD.t3 IDACDISABLE a_10262_923# PDACVDD.t0 sg13_hv_pmos ad=0.228p pd=1.58u as=0.408p ps=3.08u w=1.2u l=0.6u
X23 a_6010_3288# a_5746_3288# PDACVSS.t194 rhigh l=15u w=0.5u
X24 ODACOUT.t51 a_13474_923.t23 PDACVSS.t230 PDACVSS.t221 sg13_hv_nmos ad=0.408p pd=3.08u as=0.408p ps=3.08u w=1.2u l=0.6u
X25 PDACVSS.t246 a_13474_923.t20 ODACOUT.t33 PDACVSS.t223 sg13_hv_nmos ad=0.408p pd=3.08u as=0.408p ps=3.08u w=1.2u l=0.6u
X26 a_11732_5295# a_8700_4135# a_11732_5491# PDACVDD.t0 sg13_hv_pmos ad=0.228p pd=1.58u as=0.408p ps=3.08u w=1.2u l=0.6u
X27 PDACVSS.t226 a_13474_923.t24 ODACOUT.t42 PDACVSS.t225 sg13_hv_nmos ad=0.408p pd=3.08u as=0.408p ps=3.08u w=1.2u l=0.6u
X28 ODACOUT.t4 a_12980_5491.t17 PDACVDD.t142 PDACVDD.t0 sg13_hv_pmos ad=0.816p pd=5.48u as=0.816p ps=5.48u w=2.4u l=0.4u
X29 a_1258_3288# a_994_3288# PDACVSS.t10 rhigh l=15u w=0.5u
X30 PDACVSS.t207 IDACIREF PDACVSS.t206 PDACVSS.t205 sg13_hv_nmos ad=0.204p pd=1.88u as=0 ps=0 w=0.6u l=2.4u
X31 PDACVSS.t167 a_10180_247# a_10846_727# PDACVSS.t34 sg13_hv_nmos ad=0.204p pd=1.88u as=0.114p ps=0.98u w=0.6u l=2.4u
X32 PDACVSS.t182 a_11732_5491# a_13474_727# PDACVSS.t41 sg13_hv_nmos ad=0.204p pd=1.88u as=0.114p ps=0.98u w=0.6u l=2.4u
X33 PDACVDD.t12 PDACVDD.t10 PDACVDD.t11 PDACVDD.t0 sg13_hv_pmos ad=0.816p pd=5.48u as=0 ps=0 w=2.4u l=0.4u
X34 PDACVDD.t57 PDACVDD.t52 PDACVDD.t56 PDACVDD.t0 sg13_hv_pmos ad=0.816p pd=5.48u as=0 ps=0 w=2.4u l=0.4u
X35 PDACVDD.t64 a_10714_5055# a_11732_5295# PDACVDD.t0 sg13_hv_pmos ad=0.408p pd=3.08u as=0.228p ps=1.58u w=1.2u l=1.2u
X36 a_11108_5819# a_8700_4135# a_10714_5055# PDACVDD.t0 sg13_hv_pmos ad=0.228p pd=1.58u as=0.408p ps=3.08u w=1.2u l=0.6u
X37 a_11732_5491# a_8700_4135# a_11732_5295# PDACVDD.t0 sg13_hv_pmos ad=0.408p pd=3.08u as=0.228p ps=1.58u w=1.2u l=0.6u
X38 a_11732_5295# op_amp_ver_2_0.IOAM a_10846_923# PDACVSS.t14 sg13_hv_nmos ad=0.816p pd=5.48u as=0.816p ps=5.48u w=2.4u l=0.45u
X39 PDACVSS.t147 PDACVSS.t145 PDACVSS.t146 PDACVSS.t108 sg13_hv_nmos ad=0.408p pd=3.08u as=0 ps=0 w=1.2u l=0.6u
X40 ODACOUT.t38 a_13474_923.t19 PDACVSS.t251 PDACVSS.t223 sg13_hv_nmos ad=0.408p pd=3.08u as=0.408p ps=3.08u w=1.2u l=0.6u
X41 PDACVSS.t135 PDACVSS.t133 PDACVSS.t134 PDACVSS.t108 sg13_hv_nmos ad=0.408p pd=3.08u as=0 ps=0 w=1.2u l=0.6u
X42 a_10846_727# a_10180_247# PDACVSS.t171 PDACVSS.t33 sg13_hv_nmos ad=0.114p pd=0.98u as=0.204p ps=1.88u w=0.6u l=2.4u
X43 PDACVDD.t71 a_10714_5055# a_11108_5819# PDACVDD.t0 sg13_hv_pmos ad=0.408p pd=3.08u as=0.228p ps=1.58u w=1.2u l=1.2u
X44 a_12306_727# a_8780_247# a_11732_5491# PDACVSS.t36 sg13_hv_nmos ad=0.114p pd=0.98u as=0.204p ps=1.88u w=0.6u l=0.6u
X45 PDACVSS.t245 a_13474_923.t20 ODACOUT.t48 PDACVSS.t221 sg13_hv_nmos ad=0.408p pd=3.08u as=0.408p ps=3.08u w=1.2u l=0.6u
X46 a_10846_923# a_8780_247# a_10846_727# PDACVSS.t33 sg13_hv_nmos ad=0.204p pd=1.88u as=0.114p ps=0.98u w=0.6u l=0.6u
X47 PDACVDD.t9 PDACVDD.t7 PDACVDD.t8 PDACVDD.t0 sg13_hv_pmos ad=0.816p pd=5.48u as=0 ps=0 w=2.4u l=0.4u
X48 ODACOUT.t24 a_12980_5491.t21 PDACVDD.t123 PDACVDD.t0 sg13_hv_pmos ad=0.816p pd=5.48u as=0.816p ps=5.48u w=2.4u l=0.4u
X49 ODACOUT.t21 a_12980_5491.t21 PDACVDD.t124 PDACVDD.t0 sg13_hv_pmos ad=0.816p pd=5.48u as=0.816p ps=5.48u w=2.4u l=0.4u
X50 PDACVDD.t60 PDACVDD.t58 PDACVDD.t59 PDACVDD.t0 sg13_hv_pmos ad=0.816p pd=5.48u as=0 ps=0 w=2.4u l=0.4u
X51 a_5218_3288# a_4954_3288# PDACVSS.t218 rhigh l=15u w=0.5u
X52 a_12306_727# a_11732_5491# PDACVSS.t186 PDACVSS.t37 sg13_hv_nmos ad=0.114p pd=0.98u as=0.204p ps=1.88u w=0.6u l=2.4u
X53 a_7280_4421# IDACDISABLE ODACOUT w_7156_4139# sg13_hv_pmos ad=0.68p pd=4.68u as=0.68p ps=4.68u w=2u l=0.45u
X54 a_11732_5491# a_8780_247# a_12306_727# PDACVSS.t37 sg13_hv_nmos ad=0.204p pd=1.88u as=0.114p ps=0.98u w=0.6u l=0.6u
X55 a_994_3288# a_730_3288# PDACVSS.t192 rhigh l=15u w=0.5u
X56 a_12014_1063# a_12014_1063# a_15606_247# PDACVSS.t104 sg13_hv_nmos ad=0.408p pd=3.08u as=0.408p ps=3.08u w=1.2u l=0.6u
X57 a_4426_3288# a_4162_3288# PDACVSS.t0 rhigh l=15u w=0.5u
X58 PDACVSS.t178 a_11732_5491# a_12306_727# PDACVSS.t37 sg13_hv_nmos ad=0.204p pd=1.88u as=0.114p ps=0.98u w=0.6u l=2.4u
X59 a_13474_727# a_11732_5491# PDACVSS.t191 PDACVSS.t42 sg13_hv_nmos ad=0.114p pd=0.98u as=0.204p ps=1.88u w=0.6u l=2.4u
X60 PDACVDD.t54 PDACVDD.t52 PDACVDD.t53 PDACVDD.t0 sg13_hv_pmos ad=0.816p pd=5.48u as=0 ps=0 w=2.4u l=0.4u
X61 a_12463_2551# a_8700_4135# a_12980_5491.t8 PDACVDD.t0 sg13_hv_pmos ad=0.228p pd=1.58u as=0.408p ps=3.08u w=1.2u l=0.6u
X62 PDACVSS.t90 PDACVSS.t88 PDACVSS.t89 PDACVSS.t63 sg13_hv_nmos ad=0.408p pd=3.08u as=0 ps=0 w=1.2u l=0.45u
X63 PDACVSS.t234 a_13474_923.t22 ODACOUT.t47 PDACVSS.t219 sg13_hv_nmos ad=0.408p pd=3.08u as=0.408p ps=3.08u w=1.2u l=0.6u
X64 a_13474_923.t11 a_8780_247# a_13474_727# PDACVSS.t42 sg13_hv_nmos ad=0.204p pd=1.88u as=0.114p ps=0.98u w=0.6u l=0.6u
X65 PDACVDD.t127 a_12980_5491.t20 ODACOUT.t10 PDACVDD.t0 sg13_hv_pmos ad=0.816p pd=5.48u as=0.816p ps=5.48u w=2.4u l=0.4u
X66 PDACVSS.t60 a_10180_247# PDACVSS.t160 PDACVSS.t57 sg13_hv_nmos ad=0.204p pd=1.88u as=0 ps=0 w=0.6u l=2.4u
X67 PDACVSS.t132 PDACVSS.t130 PDACVSS.t131 PDACVSS.t101 sg13_hv_nmos ad=0.408p pd=3.08u as=0 ps=0 w=1.2u l=0.6u
X68 a_13474_923.t3 a_12014_923# a_12980_5491.t2 PDACVDD.t0 sg13_hv_pmos ad=0.816p pd=5.48u as=0.816p ps=5.48u w=2.4u l=0.4u
X69 PDACVSS.t48 PDACVSS.t49 PDACVSS.t47 rhigh l=15u w=0.5u
X70 a_3634_3288# a_3370_3288# PDACVSS.t11 rhigh l=15u w=0.5u
X71 a_10846_923# op_amp_ver_2_0.IOAM a_11732_5295# PDACVSS.t15 sg13_hv_nmos ad=0.816p pd=5.48u as=0.816p ps=5.48u w=2.4u l=0.45u
X72 PDACVDD.t74 a_10714_5055# a_12463_2551# PDACVDD.t0 sg13_hv_pmos ad=0.408p pd=3.08u as=0.228p ps=1.58u w=1.2u l=1.2u
X73 PDACVDD.t110 a_12980_5491.t24 ODACOUT.t13 PDACVDD.t0 sg13_hv_pmos ad=0.816p pd=5.48u as=0.816p ps=5.48u w=2.4u l=0.4u
X74 PDACVDD.t141 a_12980_5491.t18 ODACOUT.t4 PDACVDD.t0 sg13_hv_pmos ad=0.816p pd=5.48u as=0.816p ps=5.48u w=2.4u l=0.4u
X75 PDACVSS.t144 PDACVSS.t142 PDACVSS.t143 PDACVSS.t101 sg13_hv_nmos ad=0.408p pd=3.08u as=0 ps=0 w=1.2u l=0.6u
X76 PDACVSS.t75 PDACVSS.t72 PDACVSS.t74 PDACVSS.t73 sg13_hv_nmos ad=0.408p pd=3.08u as=0 ps=0 w=1.2u l=0.45u
X77 a_2842_3288# a_2578_3288# PDACVSS.t4 rhigh l=15u w=0.5u
X78 a_12463_2551# a_10714_5055# PDACVDD.t86 PDACVDD.t0 sg13_hv_pmos ad=0.228p pd=1.58u as=0.408p ps=3.08u w=1.2u l=1.2u
X79 PDACVDD.t36 PDACVDD.t34 PDACVDD.t35 PDACVDD.t0 sg13_hv_pmos ad=0.816p pd=5.48u as=0 ps=0 w=2.4u l=0.4u
X80 ODACOUT.t45 a_13474_923.t21 PDACVSS.t241 PDACVSS.t223 sg13_hv_nmos ad=0.408p pd=3.08u as=0.408p ps=3.08u w=1.2u l=0.6u
X81 ODACOUT.t39 a_13474_923.t17 PDACVSS.t260 PDACVSS.t221 sg13_hv_nmos ad=0.408p pd=3.08u as=0.408p ps=3.08u w=1.2u l=0.6u
X82 a_12980_5491.t13 a_12014_1063# a_13474_923.t13 PDACVSS.t104 sg13_hv_nmos ad=0.408p pd=3.08u as=0.408p ps=3.08u w=1.2u l=0.6u
X83 a_9552_4067# a_8700_4135# a_8700_4135# PDACVDD.t0 sg13_hv_pmos ad=0.34p pd=2.68u as=0.34p ps=2.68u w=1u l=10u
X84 a_11732_5295# a_10714_5055# PDACVDD.t83 PDACVDD.t0 sg13_hv_pmos ad=0.228p pd=1.58u as=0.408p ps=3.08u w=1.2u l=1.2u
X85 ODACOUT.t16 a_12980_5491.t17 PDACVDD.t145 PDACVDD.t0 sg13_hv_pmos ad=0.816p pd=5.48u as=0.816p ps=5.48u w=2.4u l=0.4u
X86 PDACVSS.t18 a_8780_247# PDACVSS.t17 PDACVSS.t16 sg13_hv_nmos ad=0.136p pd=1.48u as=0 ps=0 w=0.4u l=10u
X87 PDACVSS.t21 a_10180_247# PDACVSS.t161 PDACVSS.t19 sg13_hv_nmos ad=0.204p pd=1.88u as=0 ps=0 w=0.6u l=2.4u
X88 a_10554_727# a_10180_247# PDACVSS.t168 PDACVSS.t19 sg13_hv_nmos ad=0.114p pd=0.98u as=0.204p ps=1.88u w=0.6u l=2.4u
X89 PDACVSS.t78 PDACVSS.t76 PDACVSS.t77 PDACVSS.t63 sg13_hv_nmos ad=0.408p pd=3.08u as=0 ps=0 w=1.2u l=0.45u
X90 PDACVDD.t70 a_10714_5055# PDACVDD.t69 PDACVDD.t0 sg13_hv_pmos ad=0.228p pd=1.58u as=0 ps=0 w=1.2u l=1.2u
X91 a_7384_3755# IDACDISABLE PDACVSS.t56 PDACVSS.t55 sg13_hv_nmos ad=0.102p pd=1.28u as=0.102p ps=1.28u w=0.3u l=0.45u
X92 ODACOUT.t36 a_13474_923.t23 PDACVSS.t233 PDACVSS.t227 sg13_hv_nmos ad=0.408p pd=3.08u as=0.408p ps=3.08u w=1.2u l=0.6u
X93 PDACVSS.t257 a_13474_923.t18 ODACOUT.t50 PDACVSS.t225 sg13_hv_nmos ad=0.408p pd=3.08u as=0.408p ps=3.08u w=1.2u l=0.6u
X94 a_11732_5295# a_8700_4135# a_11732_5491# PDACVDD.t0 sg13_hv_pmos ad=0.228p pd=1.58u as=0.408p ps=3.08u w=1.2u l=0.6u
X95 a_10180_247# a_8780_247# a_10554_727# PDACVSS.t19 sg13_hv_nmos ad=0.204p pd=1.88u as=0.114p ps=0.98u w=0.6u l=0.6u
X96 PDACVDD.t33 PDACVDD.t31 PDACVDD.t32 PDACVDD.t0 sg13_hv_pmos ad=0.816p pd=5.48u as=0 ps=0 w=2.4u l=0.4u
X97 a_6802_3288# op_amp_ver_2_0.IOAM PDACVSS.t199 rhigh l=15u w=0.5u
X98 PDACVDD.t108 a_12980_5491.t24 ODACOUT.t28 PDACVDD.t0 sg13_hv_pmos ad=0.816p pd=5.48u as=0.816p ps=5.48u w=2.4u l=0.4u
X99 PDACVDD.t109 a_12980_5491.t24 ODACOUT.t19 PDACVDD.t0 sg13_hv_pmos ad=0.816p pd=5.48u as=0.816p ps=5.48u w=2.4u l=0.4u
X100 ODACOUT.t23 a_12980_5491.t23 PDACVDD.t112 PDACVDD.t0 sg13_hv_pmos ad=0.816p pd=5.48u as=0.816p ps=5.48u w=2.4u l=0.4u
X101 a_10846_923# IDACVTAP a_12463_2551# PDACVSS.t14 sg13_hv_nmos ad=0.816p pd=5.48u as=0.816p ps=5.48u w=2.4u l=0.45u
X102 a_12014_727# a_10180_247# PDACVSS.t173 PDACVSS.t46 sg13_hv_nmos ad=0.114p pd=0.98u as=0.204p ps=1.88u w=0.6u l=2.4u
X103 PDACVDD.t63 a_10714_5055# a_11732_5295# PDACVDD.t0 sg13_hv_pmos ad=0.408p pd=3.08u as=0.228p ps=1.58u w=1.2u l=1.2u
X104 a_15859_6052# a_12014_923# a_12014_923# PDACVDD.t0 sg13_hv_pmos ad=0.816p pd=5.48u as=0.816p ps=5.48u w=2.4u l=0.4u
X105 a_10846_727# a_8780_247# a_10846_923# PDACVSS.t33 sg13_hv_nmos ad=0.114p pd=0.98u as=0.204p ps=1.88u w=0.6u l=0.6u
X106 PDACVDD.t97 a_8700_4135# PDACVDD.t96 PDACVDD.t0 sg13_hv_pmos ad=0.34p pd=2.68u as=0 ps=0 w=1u l=10u
X107 ODACOUT.t5 a_12980_5491.t21 PDACVDD.t126 PDACVDD.t0 sg13_hv_pmos ad=0.816p pd=5.48u as=0.816p ps=5.48u w=2.4u l=0.4u
X108 PDACVSS.t164 a_10180_247# a_10846_727# PDACVSS.t31 sg13_hv_nmos ad=0.204p pd=1.88u as=0.114p ps=0.98u w=0.6u l=2.4u
X109 ODACOUT.t44 a_13474_923.t21 PDACVSS.t240 PDACVSS.t221 sg13_hv_nmos ad=0.408p pd=3.08u as=0.408p ps=3.08u w=1.2u l=0.6u
X110 PDACVSS.t237 a_13474_923.t22 ODACOUT.t54 PDACVSS.t225 sg13_hv_nmos ad=0.408p pd=3.08u as=0.408p ps=3.08u w=1.2u l=0.6u
X111 a_12014_923# a_8780_247# a_12014_727# PDACVSS.t46 sg13_hv_nmos ad=0.204p pd=1.88u as=0.114p ps=0.98u w=0.6u l=0.6u
X112 PDACVSS.t254 a_13474_923.t18 ODACOUT.t35 PDACVSS.t219 sg13_hv_nmos ad=0.408p pd=3.08u as=0.408p ps=3.08u w=1.2u l=0.6u
X113 a_13474_727# a_11732_5491# PDACVSS.t188 PDACVSS.t39 sg13_hv_nmos ad=0.114p pd=0.98u as=0.204p ps=1.88u w=0.6u l=2.4u
X114 a_4162_3288# a_3370_3288# PDACVSS.t12 rhigh l=15u w=0.5u
X115 PDACVSS.t248 a_13474_923.t20 ODACOUT.t46 PDACVSS.t227 sg13_hv_nmos ad=0.408p pd=3.08u as=0.408p ps=3.08u w=1.2u l=0.6u
X116 a_13474_923.t8 a_8780_247# a_13474_727# PDACVSS.t39 sg13_hv_nmos ad=0.204p pd=1.88u as=0.114p ps=0.98u w=0.6u l=0.6u
X117 a_12980_5491.t10 a_8700_4135# a_12463_2551# PDACVDD.t0 sg13_hv_pmos ad=0.408p pd=3.08u as=0.228p ps=1.58u w=1.2u l=0.6u
X118 PDACVDD.t18 PDACVDD.t16 PDACVDD.t17 PDACVDD.t0 sg13_hv_pmos ad=0.816p pd=5.48u as=0 ps=0 w=2.4u l=0.4u
X119 ODACOUT.t7 a_12980_5491.t17 PDACVDD.t143 PDACVDD.t0 sg13_hv_pmos ad=0.816p pd=5.48u as=0.816p ps=5.48u w=2.4u l=0.4u
X120 ODACOUT.t14 a_12980_5491.t17 PDACVDD.t144 PDACVDD.t0 sg13_hv_pmos ad=0.816p pd=5.48u as=0.816p ps=5.48u w=2.4u l=0.4u
X121 PDACVSS.t110 PDACVSS.t107 PDACVSS.t109 PDACVSS.t108 sg13_hv_nmos ad=0.408p pd=3.08u as=0 ps=0 w=1.2u l=0.6u
X122 a_11732_5491# a_8700_4135# a_11732_5295# PDACVDD.t0 sg13_hv_pmos ad=0.408p pd=3.08u as=0.228p ps=1.58u w=1.2u l=0.6u
X123 PDACVDD.t130 a_12980_5491.t20 ODACOUT.t11 PDACVDD.t0 sg13_hv_pmos ad=0.816p pd=5.48u as=0.816p ps=5.48u w=2.4u l=0.4u
X124 a_3370_3288# a_2578_3288# PDACVSS.t2 rhigh l=15u w=0.5u
X125 a_13474_727# a_8780_247# a_13474_923.t6 PDACVSS.t41 sg13_hv_nmos ad=0.114p pd=0.98u as=0.204p ps=1.88u w=0.6u l=0.6u
X126 a_10846_727# a_8780_247# a_10846_923# PDACVSS.t34 sg13_hv_nmos ad=0.114p pd=0.98u as=0.204p ps=1.88u w=0.6u l=0.6u
X127 PDACVDD.t102 a_8700_4135# PDACVDD.t70 PDACVDD.t0 sg13_hv_pmos ad=0.408p pd=3.08u as=0 ps=0 w=1.2u l=0.6u
X128 a_8780_247# a_8780_247# a_9424_2247# PDACVSS.t27 sg13_hv_nmos ad=0.136p pd=1.48u as=0.136p ps=1.48u w=0.4u l=10u
X129 PDACVDD.t15 PDACVDD.t13 PDACVDD.t14 PDACVDD.t0 sg13_hv_pmos ad=0.816p pd=5.48u as=0 ps=0 w=2.4u l=0.4u
X130 IDACIREF IDACIREF PDACVSS.t209 PDACVSS.t208 sg13_hv_nmos ad=0.204p pd=1.88u as=0.204p ps=1.88u w=0.6u l=2.4u
X131 PDACVSS.t183 a_11732_5491# a_13474_727# PDACVSS.t42 sg13_hv_nmos ad=0.204p pd=1.88u as=0.114p ps=0.98u w=0.6u l=2.4u
X132 PDACVSS.t159 PDACVSS.t157 PDACVSS.t158 PDACVSS.t108 sg13_hv_nmos ad=0.408p pd=3.08u as=0 ps=0 w=1.2u l=0.6u
X133 ODACOUT.t40 a_13474_923.t17 PDACVSS.t261 PDACVSS.t223 sg13_hv_nmos ad=0.408p pd=3.08u as=0.408p ps=3.08u w=1.2u l=0.6u
X134 a_13474_923.t16 a_12014_1063# a_12980_5491.t16 PDACVSS.t104 sg13_hv_nmos ad=0.408p pd=3.08u as=0.408p ps=3.08u w=1.2u l=0.6u
X135 PDACVSS.t202 PDACVSS.t203 PDACVSS.t201 rhigh l=15u w=0.5u
X136 PDACVSS.t30 a_8780_247# PDACVSS.t29 PDACVSS.t28 sg13_hv_nmos ad=0.136p pd=1.48u as=0 ps=0 w=0.4u l=10u
X137 PDACVSS.t103 PDACVSS.t100 PDACVSS.t102 PDACVSS.t101 sg13_hv_nmos ad=0.408p pd=3.08u as=0 ps=0 w=1.2u l=0.6u
X138 PDACVDD.t92 a_10714_5055# PDACVDD.t91 PDACVDD.t0 sg13_hv_pmos ad=0.228p pd=1.58u as=0 ps=0 w=1.2u l=1.2u
X139 a_12463_2551# a_10714_5055# PDACVDD.t85 PDACVDD.t0 sg13_hv_pmos ad=0.228p pd=1.58u as=0.408p ps=3.08u w=1.2u l=1.2u
X140 a_2578_3288# a_1786_3288# PDACVSS.t51 rhigh l=15u w=0.5u
X141 a_10846_727# a_10180_247# PDACVSS.t170 PDACVSS.t32 sg13_hv_nmos ad=0.114p pd=0.98u as=0.204p ps=1.88u w=0.6u l=2.4u
X142 a_12463_2551# a_10714_5055# PDACVDD.t87 PDACVDD.t0 sg13_hv_pmos ad=0.228p pd=1.58u as=0.408p ps=3.08u w=1.2u l=1.2u
X143 PDACVDD.t128 a_12980_5491.t20 ODACOUT.t12 PDACVDD.t0 sg13_hv_pmos ad=0.816p pd=5.48u as=0.816p ps=5.48u w=2.4u l=0.4u
X144 PDACVDD.t129 a_12980_5491.t20 ODACOUT.t3 PDACVDD.t0 sg13_hv_pmos ad=0.816p pd=5.48u as=0.816p ps=5.48u w=2.4u l=0.4u
X145 a_12306_727# a_8780_247# a_11732_5491# PDACVSS.t37 sg13_hv_nmos ad=0.114p pd=0.98u as=0.204p ps=1.88u w=0.6u l=0.6u
X146 a_10846_923# a_8780_247# a_10846_727# PDACVSS.t32 sg13_hv_nmos ad=0.204p pd=1.88u as=0.114p ps=0.98u w=0.6u l=0.6u
X147 ODACOUT.t9 a_12980_5491.t23 PDACVDD.t115 PDACVDD.t0 sg13_hv_pmos ad=0.816p pd=5.48u as=0.816p ps=5.48u w=2.4u l=0.4u
X148 PDACVSS.t84 PDACVSS.t82 PDACVSS.t83 PDACVSS.t63 sg13_hv_nmos ad=0.408p pd=3.08u as=0 ps=0 w=1.2u l=0.45u
X149 PDACVSS.t44 PDACVSS.t120 PDACVSS.t121 PDACVSS.t43 sg13_hv_nmos ad=0.204p pd=1.88u as=0 ps=0 w=0.6u l=2.4u
X150 a_12306_727# a_11732_5491# PDACVSS.t185 PDACVSS.t36 sg13_hv_nmos ad=0.114p pd=0.98u as=0.204p ps=1.88u w=0.6u l=2.4u
X151 PDACVDD.t111 a_12980_5491.t24 ODACOUT.t18 PDACVDD.t0 sg13_hv_pmos ad=0.816p pd=5.48u as=0.816p ps=5.48u w=2.4u l=0.4u
X152 a_1786_3288# a_994_3288# PDACVSS.t5 rhigh l=15u w=0.5u
X153 PDACVSS.t258 a_13474_923.t18 ODACOUT.t32 PDACVSS.t227 sg13_hv_nmos ad=0.408p pd=3.08u as=0.408p ps=3.08u w=1.2u l=0.6u
X154 PDACVSS.t60 IDACDISABLE IDACIREF PDACVSS.t57 sg13_hv_nmos ad=0.114p pd=0.98u as=0.204p ps=1.88u w=0.6u l=0.6u
X155 PDACVSS.t224 a_13474_923.t24 ODACOUT.t59 PDACVSS.t223 sg13_hv_nmos ad=0.408p pd=3.08u as=0.408p ps=3.08u w=1.2u l=0.6u
X156 ODACOUT.t36 a_13474_923.t23 PDACVSS.t229 PDACVSS.t219 sg13_hv_nmos ad=0.408p pd=3.08u as=0.408p ps=3.08u w=1.2u l=0.6u
X157 op_amp_ver_2_0.IOAM a_5746_3288# PDACVSS.t54 rhigh l=15u w=0.5u
X158 PDACVSS.t59 a_10180_247# PDACVSS.t162 PDACVSS.t46 sg13_hv_nmos ad=0.204p pd=1.88u as=0 ps=0 w=0.6u l=2.4u
X159 a_11732_5491# a_8780_247# a_12306_727# PDACVSS.t36 sg13_hv_nmos ad=0.204p pd=1.88u as=0.114p ps=0.98u w=0.6u l=0.6u
X160 ODACOUT.t10 a_12980_5491.t19 PDACVDD.t132 PDACVDD.t0 sg13_hv_pmos ad=0.816p pd=5.48u as=0.816p ps=5.48u w=2.4u l=0.4u
X161 a_12980_5491.t3 a_12014_923# a_13474_923.t2 PDACVDD.t0 sg13_hv_pmos ad=0.816p pd=5.48u as=0.816p ps=5.48u w=2.4u l=0.4u
X162 a_13474_727# a_11732_5491# PDACVSS.t190 PDACVSS.t41 sg13_hv_nmos ad=0.114p pd=0.98u as=0.204p ps=1.88u w=0.6u l=2.4u
X163 ODACOUT.t4 a_12980_5491.t17 PDACVDD.t146 PDACVDD.t0 sg13_hv_pmos ad=0.816p pd=5.48u as=0.816p ps=5.48u w=2.4u l=0.4u
X164 PDACVSS.t156 PDACVSS.t154 PDACVSS.t155 PDACVSS.t101 sg13_hv_nmos ad=0.408p pd=3.08u as=0 ps=0 w=1.2u l=0.6u
X165 ODACOUT.t58 a_13474_923.t19 PDACVSS.t252 PDACVSS.t225 sg13_hv_nmos ad=0.408p pd=3.08u as=0.408p ps=3.08u w=1.2u l=0.6u
X166 a_12463_2551# a_8700_4135# a_12980_5491.t6 PDACVDD.t0 sg13_hv_pmos ad=0.228p pd=1.58u as=0.408p ps=3.08u w=1.2u l=0.6u
X167 a_5746_3288# a_4954_3288# PDACVSS.t175 rhigh l=15u w=0.5u
X168 ODACOUT.t47 a_13474_923.t21 PDACVSS.t243 PDACVSS.t227 sg13_hv_nmos ad=0.408p pd=3.08u as=0.408p ps=3.08u w=1.2u l=0.6u
X169 a_13474_923.t10 a_8780_247# a_13474_727# PDACVSS.t41 sg13_hv_nmos ad=0.204p pd=1.88u as=0.114p ps=0.98u w=0.6u l=0.6u
X170 PDACVSS.t196 PDACVSS.t197 PDACVSS.t195 rhigh l=14u w=0.5u
X171 PDACVDD.t92 a_8700_4135# PDACVDD.t106 PDACVDD.t0 sg13_hv_pmos ad=0.408p pd=3.08u as=0 ps=0 w=1.2u l=0.6u
X172 PDACVSS.t21 a_8780_247# PDACVSS.t20 PDACVSS.t19 sg13_hv_nmos ad=0.114p pd=0.98u as=0 ps=0 w=0.6u l=0.6u
X173 a_11732_5295# a_8700_4135# a_11732_5491# PDACVDD.t0 sg13_hv_pmos ad=0.228p pd=1.58u as=0.408p ps=3.08u w=1.2u l=0.6u
X174 a_12980_5491.t9 a_8700_4135# a_12463_2551# PDACVDD.t0 sg13_hv_pmos ad=0.408p pd=3.08u as=0.228p ps=1.58u w=1.2u l=0.6u
X175 a_11420_5295# a_10714_5055# PDACVDD.t80 PDACVDD.t0 sg13_hv_pmos ad=0.228p pd=1.58u as=0.408p ps=3.08u w=1.2u l=1.2u
X176 PDACVDD.t42 PDACVDD.t40 PDACVDD.t41 PDACVDD.t0 sg13_hv_pmos ad=0.816p pd=5.48u as=0 ps=0 w=2.4u l=0.4u
X177 PDACVSS.t116 PDACVSS.t111 PDACVSS.t115 PDACVSS.t104 sg13_hv_nmos ad=0.408p pd=3.08u as=0 ps=0 w=1.2u l=0.6u
X178 PDACVSS.t244 a_13474_923.t20 ODACOUT.t46 PDACVSS.t219 sg13_hv_nmos ad=0.408p pd=3.08u as=0.408p ps=3.08u w=1.2u l=0.6u
X179 PDACVDD.t62 a_10714_5055# a_12463_2551# PDACVDD.t0 sg13_hv_pmos ad=0.408p pd=3.08u as=0.228p ps=1.58u w=1.2u l=1.2u
X180 a_12980_5491.t11 a_8700_4135# a_12463_2551# PDACVDD.t0 sg13_hv_pmos ad=0.408p pd=3.08u as=0.228p ps=1.58u w=1.2u l=0.6u
X181 ODACOUT.t6 a_12980_5491.t23 PDACVDD.t113 PDACVDD.t0 sg13_hv_pmos ad=0.816p pd=5.48u as=0.816p ps=5.48u w=2.4u l=0.4u
X182 ODACOUT.t17 a_12980_5491.t23 PDACVDD.t114 PDACVDD.t0 sg13_hv_pmos ad=0.816p pd=5.48u as=0.816p ps=5.48u w=2.4u l=0.4u
X183 a_4954_3288# a_4162_3288# PDACVSS.t3 rhigh l=15u w=0.5u
X184 PDACVSS.t222 a_13474_923.t24 ODACOUT.t41 PDACVSS.t221 sg13_hv_nmos ad=0.408p pd=3.08u as=0.408p ps=3.08u w=1.2u l=0.6u
X185 PDACVSS.t176 a_11732_5491# a_12306_727# PDACVSS.t35 sg13_hv_nmos ad=0.204p pd=1.88u as=0.114p ps=0.98u w=0.6u l=2.4u
X186 PDACVSS.t58 a_10180_247# PDACVSS.t163 PDACVSS.t57 sg13_hv_nmos ad=0.114p pd=0.98u as=0 ps=0 w=0.6u l=2.4u
X187 PDACVDD.t68 a_8700_4135# PDACVDD.t98 PDACVDD.t0 sg13_hv_pmos ad=0.228p pd=1.58u as=0 ps=0 w=1.2u l=0.6u
X188 ODACOUT.t46 a_13474_923.t19 PDACVSS.t249 PDACVSS.t219 sg13_hv_nmos ad=0.408p pd=3.08u as=0.408p ps=3.08u w=1.2u l=0.6u
X189 PDACVDD.t72 a_10714_5055# a_11732_5295# PDACVDD.t0 sg13_hv_pmos ad=0.408p pd=3.08u as=0.228p ps=1.58u w=1.2u l=1.2u
X190 a_9272_2247# a_8780_247# a_9120_2247# PDACVSS.t25 sg13_hv_nmos ad=0.136p pd=1.48u as=0.136p ps=1.48u w=0.4u l=10u
X191 a_10262_923# IDACDISABLE PDACVSS.t58 PDACVSS.t57 sg13_hv_nmos ad=0.204p pd=1.88u as=0.114p ps=0.98u w=0.6u l=0.6u
X192 PDACVSS.t179 a_11732_5491# a_12306_727# PDACVSS.t38 sg13_hv_nmos ad=0.204p pd=1.88u as=0.114p ps=0.98u w=0.6u l=2.4u
X193 PDACVDD.t68 a_10714_5055# PDACVDD.t67 PDACVDD.t0 sg13_hv_pmos ad=0.408p pd=3.08u as=0 ps=0 w=1.2u l=1.2u
X194 a_730_3288# a_466_3288# PDACVSS.t174 rhigh l=15u w=0.5u
X195 PDACVSS.t71 PDACVSS.t66 PDACVSS.t70 PDACVSS.t15 sg13_hv_nmos ad=0.816p pd=5.48u as=0 ps=0 w=2.4u l=0.45u
X196 PDACVSS.t99 PDACVSS.t97 PDACVSS.t98 PDACVSS.t73 sg13_hv_nmos ad=0.408p pd=3.08u as=0 ps=0 w=1.2u l=0.45u
X197 PDACVDD.t39 PDACVDD.t37 PDACVDD.t38 PDACVDD.t0 sg13_hv_pmos ad=0.816p pd=5.48u as=0 ps=0 w=2.4u l=0.4u
X198 PDACVSS.t129 PDACVSS.t127 PDACVSS.t128 PDACVSS.t108 sg13_hv_nmos ad=0.408p pd=3.08u as=0 ps=0 w=1.2u l=0.6u
X199 a_10846_727# a_8780_247# a_10846_923# PDACVSS.t31 sg13_hv_nmos ad=0.114p pd=0.98u as=0.204p ps=1.88u w=0.6u l=0.6u
X200 PDACVDD.t117 a_12980_5491.t22 ODACOUT.t1 PDACVDD.t0 sg13_hv_pmos ad=0.816p pd=5.48u as=0.816p ps=5.48u w=2.4u l=0.4u
X201 a_9424_2247# a_8780_247# a_9272_2247# PDACVSS.t26 sg13_hv_nmos ad=0.136p pd=1.48u as=0.136p ps=1.48u w=0.4u l=10u
X202 a_10714_5055# IDACIREF PDACVSS.t214 PDACVSS.t213 sg13_hv_nmos ad=0.204p pd=1.88u as=0.204p ps=1.88u w=0.6u l=2.4u
X203 a_9280_4067# a_8700_4135# a_9552_4067# PDACVDD.t0 sg13_hv_pmos ad=0.34p pd=2.68u as=0.34p ps=2.68u w=1u l=10u
X204 a_13474_923.t1 a_12014_923# a_12980_5491.t0 PDACVDD.t0 sg13_hv_pmos ad=0.816p pd=5.48u as=0.816p ps=5.48u w=2.4u l=0.4u
X205 ODACOUT.t43 a_13474_923.t23 PDACVSS.t232 PDACVSS.t225 sg13_hv_nmos ad=0.408p pd=3.08u as=0.408p ps=3.08u w=1.2u l=0.6u
X206 a_12980_5491.t15 a_12014_1063# a_13474_923.t15 PDACVSS.t104 sg13_hv_nmos ad=0.408p pd=3.08u as=0.408p ps=3.08u w=1.2u l=0.6u
X207 a_12306_727# a_11732_5491# PDACVSS.t187 PDACVSS.t38 sg13_hv_nmos ad=0.114p pd=0.98u as=0.204p ps=1.88u w=0.6u l=2.4u
X208 PDACVDD.t131 a_12980_5491.t20 ODACOUT.t10 PDACVDD.t0 sg13_hv_pmos ad=0.816p pd=5.48u as=0.816p ps=5.48u w=2.4u l=0.4u
X209 nD7 a_6802_3288# PDACVSS.t198 rhigh l=15u w=0.5u
X210 PDACVSS.t180 a_11732_5491# a_13474_727# PDACVSS.t39 sg13_hv_nmos ad=0.204p pd=1.88u as=0.114p ps=0.98u w=0.6u l=2.4u
X211 a_11732_5491# a_8780_247# a_12306_727# PDACVSS.t38 sg13_hv_nmos ad=0.204p pd=1.88u as=0.114p ps=0.98u w=0.6u l=0.6u
X212 a_8780_247# a_8700_4135# a_11420_5295# PDACVDD.t0 sg13_hv_pmos ad=0.408p pd=3.08u as=0.228p ps=1.58u w=1.2u l=0.6u
X213 PDACVDD.t24 PDACVDD.t22 PDACVDD.t23 PDACVDD.t0 sg13_hv_pmos ad=0.816p pd=5.48u as=0 ps=0 w=2.4u l=0.4u
X214 nD6 a_6010_3288# PDACVSS.t193 rhigh l=15u w=0.5u
X215 ODACOUT.t29 a_12980_5491.t19 PDACVDD.t135 PDACVDD.t0 sg13_hv_pmos ad=0.816p pd=5.48u as=0.816p ps=5.48u w=2.4u l=0.4u
X216 PDACVSS.t81 PDACVSS.t79 PDACVSS.t80 PDACVSS.t73 sg13_hv_nmos ad=0.408p pd=3.08u as=0 ps=0 w=1.2u l=0.45u
X217 PDACVSS.t247 a_13474_923.t20 ODACOUT.t34 PDACVSS.t225 sg13_hv_nmos ad=0.408p pd=3.08u as=0.408p ps=3.08u w=1.2u l=0.6u
X218 PDACVSS.t126 PDACVSS.t124 PDACVSS.t125 PDACVSS.t101 sg13_hv_nmos ad=0.408p pd=3.08u as=0 ps=0 w=1.2u l=0.6u
X219 PDACVSS.t68 PDACVSS.t66 PDACVSS.t67 PDACVSS.t14 sg13_hv_nmos ad=0.816p pd=5.48u as=0 ps=0 w=2.4u l=0.45u
X220 a_13474_727# a_8780_247# a_13474_923.t7 PDACVSS.t42 sg13_hv_nmos ad=0.114p pd=0.98u as=0.204p ps=1.88u w=0.6u l=0.6u
X221 nD5 a_5218_3288# PDACVSS.t13 rhigh l=15u w=0.5u
X222 PDACVDD.t21 PDACVDD.t19 PDACVDD.t20 PDACVDD.t0 sg13_hv_pmos ad=0.816p pd=5.48u as=0 ps=0 w=2.4u l=0.4u
X223 a_7280_4421# op_amp_ver_2_0.IOAM PDACVSS.t200 rhigh l=14u w=0.5u
X224 PDACVSS.t181 a_11732_5491# a_13474_727# PDACVSS.t40 sg13_hv_nmos ad=0.204p pd=1.88u as=0.114p ps=0.98u w=0.6u l=2.4u
X225 a_8700_4135# IDACIREF PDACVSS.t216 PDACVSS.t215 sg13_hv_nmos ad=0.204p pd=1.88u as=0.204p ps=1.88u w=0.6u l=2.4u
X226 a_15606_247# a_15606_247# PDACVSS.t204 PDACVSS.t104 sg13_hv_nmos ad=0.408p pd=3.08u as=0.408p ps=3.08u w=1.2u l=0.6u
X227 PDACVDD.t100 a_8700_4135# PDACVDD.t77 PDACVDD.t0 sg13_hv_pmos ad=0.228p pd=1.58u as=0 ps=0 w=1.2u l=0.6u
X228 ODACOUT.t46 a_13474_923.t19 PDACVSS.t253 PDACVSS.t227 sg13_hv_nmos ad=0.408p pd=3.08u as=0.408p ps=3.08u w=1.2u l=0.6u
X229 PDACVDD.t90 a_10714_5055# PDACVDD.t89 PDACVDD.t0 sg13_hv_pmos ad=0.228p pd=1.58u as=0 ps=0 w=1.2u l=1.2u
X230 ODACOUT.t0 a_12980_5491.t23 PDACVDD.t116 PDACVDD.t0 sg13_hv_pmos ad=0.816p pd=5.48u as=0.816p ps=5.48u w=2.4u l=0.4u
X231 nD4 a_4426_3288# PDACVSS.t6 rhigh l=15u w=0.5u
X232 PDACVSS.t165 a_10180_247# a_10846_727# PDACVSS.t32 sg13_hv_nmos ad=0.204p pd=1.88u as=0.114p ps=0.98u w=0.6u l=2.4u
X233 ODACOUT.t47 a_13474_923.t21 PDACVSS.t239 PDACVSS.t219 sg13_hv_nmos ad=0.408p pd=3.08u as=0.408p ps=3.08u w=1.2u l=0.6u
X234 a_12463_2551# a_8700_4135# a_12980_5491.t5 PDACVDD.t0 sg13_hv_pmos ad=0.228p pd=1.58u as=0.408p ps=3.08u w=1.2u l=0.6u
X235 a_11732_5295# a_10714_5055# PDACVDD.t84 PDACVDD.t0 sg13_hv_pmos ad=0.228p pd=1.58u as=0.408p ps=3.08u w=1.2u l=1.2u
X236 PDACVSS.t255 a_13474_923.t18 ODACOUT.t55 PDACVSS.t221 sg13_hv_nmos ad=0.408p pd=3.08u as=0.408p ps=3.08u w=1.2u l=0.6u
X237 PDACVSS.t236 a_13474_923.t22 ODACOUT.t53 PDACVSS.t223 sg13_hv_nmos ad=0.408p pd=3.08u as=0.408p ps=3.08u w=1.2u l=0.6u
X238 a_12463_2551# a_8700_4135# a_12980_5491.t7 PDACVDD.t0 sg13_hv_pmos ad=0.228p pd=1.58u as=0.408p ps=3.08u w=1.2u l=0.6u
X239 PDACVDD.t77 a_10714_5055# PDACVDD.t76 PDACVDD.t0 sg13_hv_pmos ad=0.408p pd=3.08u as=0 ps=0 w=1.2u l=1.2u
X240 PDACVSS.t45 a_8780_247# PDACVSS.t44 PDACVSS.t43 sg13_hv_nmos ad=0.114p pd=0.98u as=0 ps=0 w=0.6u l=0.6u
X241 PDACVDD.t61 a_10714_5055# a_12463_2551# PDACVDD.t0 sg13_hv_pmos ad=0.408p pd=3.08u as=0.228p ps=1.58u w=1.2u l=1.2u
X242 ODACOUT.t26 a_12980_5491.t19 PDACVDD.t133 PDACVDD.t0 sg13_hv_pmos ad=0.816p pd=5.48u as=0.816p ps=5.48u w=2.4u l=0.4u
X243 PDACVDD.t73 a_10714_5055# a_12463_2551# PDACVDD.t0 sg13_hv_pmos ad=0.408p pd=3.08u as=0.228p ps=1.58u w=1.2u l=1.2u
X244 ODACOUT.t30 a_12980_5491.t19 PDACVDD.t134 PDACVDD.t0 sg13_hv_pmos ad=0.816p pd=5.48u as=0.816p ps=5.48u w=2.4u l=0.4u
X245 PDACVSS.t228 a_13474_923.t24 ODACOUT.t36 PDACVSS.t227 sg13_hv_nmos ad=0.408p pd=3.08u as=0.408p ps=3.08u w=1.2u l=0.6u
X246 PDACVDD.t120 a_12980_5491.t22 ODACOUT.t8 PDACVDD.t0 sg13_hv_pmos ad=0.816p pd=5.48u as=0.816p ps=5.48u w=2.4u l=0.4u
X247 PDACVSS.t59 IDACDISABLE a_12014_1063# PDACVSS.t46 sg13_hv_nmos ad=0.114p pd=0.98u as=0.204p ps=1.88u w=0.6u l=0.6u
X248 PDACVDD.t93 a_8700_4135# a_9008_4067# PDACVDD.t0 sg13_hv_pmos ad=0.34p pd=2.68u as=0.34p ps=2.68u w=1u l=10u
X249 a_12980_5491.t4 a_10262_923# PDACVDD.t2 PDACVDD.t0 sg13_hv_pmos ad=0.408p pd=3.08u as=0.228p ps=1.58u w=1.2u l=0.6u
X250 PDACVDD.t95 a_8700_4135# PDACVDD.t94 PDACVDD.t0 sg13_hv_pmos ad=0.34p pd=2.68u as=0 ps=0 w=1u l=10u
X251 a_466_3288# PDACVSS.t9 PDACVSS.t8 rhigh l=15u w=0.5u
X252 nD3 a_3634_3288# PDACVSS.t52 rhigh l=15u w=0.5u
X253 a_9120_2247# a_8780_247# a_8968_2247# PDACVSS.t24 sg13_hv_nmos ad=0.136p pd=1.48u as=0.136p ps=1.48u w=0.4u l=10u
X254 a_13474_923.t14 a_12014_1063# a_12980_5491.t14 PDACVSS.t104 sg13_hv_nmos ad=0.408p pd=3.08u as=0.408p ps=3.08u w=1.2u l=0.6u
X255 PDACVSS.t235 a_13474_923.t22 ODACOUT.t56 PDACVSS.t221 sg13_hv_nmos ad=0.408p pd=3.08u as=0.408p ps=3.08u w=1.2u l=0.6u
X256 PDACVDD.t137 a_12980_5491.t18 ODACOUT.t4 PDACVDD.t0 sg13_hv_pmos ad=0.816p pd=5.48u as=0.816p ps=5.48u w=2.4u l=0.4u
X257 a_11732_5295# a_10714_5055# PDACVDD.t82 PDACVDD.t0 sg13_hv_pmos ad=0.228p pd=1.58u as=0.408p ps=3.08u w=1.2u l=1.2u
X258 a_8700_4135# a_10262_923# PDACVDD.t3 PDACVDD.t0 sg13_hv_pmos ad=0.408p pd=3.08u as=0.228p ps=1.58u w=1.2u l=0.6u
X259 PDACVDD.t48 PDACVDD.t43 PDACVDD.t47 PDACVDD.t0 sg13_hv_pmos ad=0.816p pd=5.48u as=0 ps=0 w=2.4u l=0.4u
X260 ODACOUT.t31 a_13474_923.t17 PDACVSS.t262 PDACVSS.t225 sg13_hv_nmos ad=0.408p pd=3.08u as=0.408p ps=3.08u w=1.2u l=0.6u
X261 PDACVDD.t90 a_8700_4135# PDACVDD.t105 PDACVDD.t0 sg13_hv_pmos ad=0.408p pd=3.08u as=0 ps=0 w=1.2u l=0.6u
X262 a_11420_5819# a_8700_4135# a_10180_247# PDACVDD.t0 sg13_hv_pmos ad=0.228p pd=1.58u as=0.408p ps=3.08u w=1.2u l=0.6u
X263 a_11732_5491# a_8700_4135# a_11732_5295# PDACVDD.t0 sg13_hv_pmos ad=0.408p pd=3.08u as=0.228p ps=1.58u w=1.2u l=0.6u
X264 PDACVDD.t79 a_10714_5055# PDACVDD.t78 PDACVDD.t0 sg13_hv_pmos ad=0.228p pd=1.58u as=0 ps=0 w=1.2u l=1.2u
X265 nD2 a_2842_3288# PDACVSS.t53 rhigh l=15u w=0.5u
X266 a_12306_727# a_8780_247# a_11732_5491# PDACVSS.t35 sg13_hv_nmos ad=0.114p pd=0.98u as=0.204p ps=1.88u w=0.6u l=0.6u
X267 PDACVSS.t65 PDACVSS.t62 PDACVSS.t64 PDACVSS.t63 sg13_hv_nmos ad=0.408p pd=3.08u as=0 ps=0 w=1.2u l=0.45u
X268 a_10846_727# a_10180_247# PDACVSS.t172 PDACVSS.t34 sg13_hv_nmos ad=0.114p pd=0.98u as=0.204p ps=1.88u w=0.6u l=2.4u
X269 PDACVDD.t51 PDACVDD.t49 PDACVDD.t50 PDACVDD.t0 sg13_hv_pmos ad=0.816p pd=5.48u as=0 ps=0 w=2.4u l=0.4u
X270 PDACVDD.t66 a_10714_5055# a_11420_5819# PDACVDD.t0 sg13_hv_pmos ad=0.408p pd=3.08u as=0.228p ps=1.58u w=1.2u l=1.2u
X271 PDACVDD.t118 a_12980_5491.t22 ODACOUT.t25 PDACVDD.t0 sg13_hv_pmos ad=0.816p pd=5.48u as=0.816p ps=5.48u w=2.4u l=0.4u
X272 PDACVDD.t119 a_12980_5491.t22 ODACOUT.t2 PDACVDD.t0 sg13_hv_pmos ad=0.816p pd=5.48u as=0.816p ps=5.48u w=2.4u l=0.4u
X273 ODACOUT.t35 a_13474_923.t17 PDACVSS.t259 PDACVSS.t219 sg13_hv_nmos ad=0.408p pd=3.08u as=0.408p ps=3.08u w=1.2u l=0.6u
X274 ODACOUT.t57 a_13474_923.t21 PDACVSS.t242 PDACVSS.t225 sg13_hv_nmos ad=0.408p pd=3.08u as=0.408p ps=3.08u w=1.2u l=0.6u
X275 a_10846_923# a_8780_247# a_10846_727# PDACVSS.t34 sg13_hv_nmos ad=0.204p pd=1.88u as=0.114p ps=0.98u w=0.6u l=0.6u
X276 a_12306_727# a_8780_247# a_11732_5491# PDACVSS.t38 sg13_hv_nmos ad=0.114p pd=0.98u as=0.204p ps=1.88u w=0.6u l=0.6u
X277 nD1 a_2050_3288# PDACVSS.t217 rhigh l=15u w=0.5u
X278 PDACVSS.t87 PDACVSS.t85 PDACVSS.t86 PDACVSS.t73 sg13_hv_nmos ad=0.408p pd=3.08u as=0 ps=0 w=1.2u l=0.45u
X279 PDACVSS.t177 a_11732_5491# a_12306_727# PDACVSS.t36 sg13_hv_nmos ad=0.204p pd=1.88u as=0.114p ps=0.98u w=0.6u l=2.4u
X280 PDACVSS.t119 PDACVSS.t117 PDACVSS.t118 PDACVSS.t108 sg13_hv_nmos ad=0.408p pd=3.08u as=0 ps=0 w=1.2u l=0.6u
X281 PDACVSS.t153 PDACVSS.t151 PDACVSS.t152 PDACVSS.t108 sg13_hv_nmos ad=0.408p pd=3.08u as=0 ps=0 w=1.2u l=0.6u
X282 PDACVSS.t256 a_13474_923.t18 ODACOUT.t49 PDACVSS.t223 sg13_hv_nmos ad=0.408p pd=3.08u as=0.408p ps=3.08u w=1.2u l=0.6u
X283 PDACVDD.t45 PDACVDD.t43 PDACVDD.t44 PDACVDD.t0 sg13_hv_pmos ad=0.816p pd=5.48u as=0 ps=0 w=2.4u l=0.4u
X284 nD0 a_1258_3288# PDACVSS.t50 rhigh l=15u w=0.5u
X285 PDACVDD.t5 IDACDISABLE a_7384_3755# w_7156_4139# sg13_hv_pmos ad=0.204p pd=1.88u as=0.204p ps=1.88u w=0.6u l=0.45u
X286 ODACOUT.t1 a_12980_5491.t21 PDACVDD.t122 PDACVDD.t0 sg13_hv_pmos ad=0.816p pd=5.48u as=0.816p ps=5.48u w=2.4u l=0.4u
X287 PDACVSS.t212 IDACIREF PDACVSS.t211 PDACVSS.t210 sg13_hv_nmos ad=0.204p pd=1.88u as=0 ps=0 w=0.6u l=2.4u
X288 PDACVSS.t61 PDACVSS.t122 PDACVSS.t123 PDACVSS.t43 sg13_hv_nmos ad=0.114p pd=0.98u as=0 ps=0 w=0.6u l=2.4u
X289 a_12980_5491.t1 a_12014_923# a_13474_923.t0 PDACVDD.t0 sg13_hv_pmos ad=0.816p pd=5.48u as=0.816p ps=5.48u w=2.4u l=0.4u
X290 a_13474_727# a_8780_247# a_13474_923.t4 PDACVSS.t39 sg13_hv_nmos ad=0.114p pd=0.98u as=0.204p ps=1.88u w=0.6u l=0.6u
X291 a_11732_5491# a_8700_4135# a_11732_5295# PDACVDD.t0 sg13_hv_pmos ad=0.408p pd=3.08u as=0.228p ps=1.58u w=1.2u l=0.6u
X292 a_12463_2551# a_10714_5055# PDACVDD.t88 PDACVDD.t0 sg13_hv_pmos ad=0.228p pd=1.58u as=0.408p ps=3.08u w=1.2u l=1.2u
X293 a_13474_923.t12 IDACDISABLE PDACVSS.t61 PDACVSS.t43 sg13_hv_nmos ad=0.204p pd=1.88u as=0.114p ps=0.98u w=0.6u l=0.6u
X294 ODACOUT.t10 a_12980_5491.t19 PDACVDD.t136 PDACVDD.t0 sg13_hv_pmos ad=0.816p pd=5.48u as=0.816p ps=5.48u w=2.4u l=0.4u
X295 PDACVDD.t104 a_8700_4135# PDACVDD.t79 PDACVDD.t0 sg13_hv_pmos ad=0.408p pd=3.08u as=0 ps=0 w=1.2u l=0.6u
X296 PDACVDD.t30 PDACVDD.t28 PDACVDD.t29 PDACVDD.t0 sg13_hv_pmos ad=0.816p pd=5.48u as=0 ps=0 w=2.4u l=0.4u
X297 PDACVSS.t96 PDACVSS.t91 PDACVSS.t95 PDACVSS.t15 sg13_hv_nmos ad=0.816p pd=5.48u as=0 ps=0 w=2.4u l=0.45u
X298 PDACVSS.t141 PDACVSS.t139 PDACVSS.t140 PDACVSS.t108 sg13_hv_nmos ad=0.408p pd=3.08u as=0 ps=0 w=1.2u l=0.6u
X299 a_9008_4067# a_8700_4135# a_9280_4067# PDACVDD.t0 sg13_hv_pmos ad=0.34p pd=2.68u as=0.34p ps=2.68u w=1u l=10u
X300 PDACVSS.t220 a_13474_923.t24 ODACOUT.t36 PDACVSS.t219 sg13_hv_nmos ad=0.408p pd=3.08u as=0.408p ps=3.08u w=1.2u l=0.6u
X301 PDACVSS.t113 PDACVSS.t111 PDACVSS.t112 PDACVSS.t101 sg13_hv_nmos ad=0.408p pd=3.08u as=0 ps=0 w=1.2u l=0.6u
X302 ODACOUT.t37 a_13474_923.t19 PDACVSS.t250 PDACVSS.t221 sg13_hv_nmos ad=0.408p pd=3.08u as=0.408p ps=3.08u w=1.2u l=0.6u
X303 PDACVDD.t140 a_12980_5491.t18 ODACOUT.t22 PDACVDD.t0 sg13_hv_pmos ad=0.816p pd=5.48u as=0.816p ps=5.48u w=2.4u l=0.4u
X304 a_13474_727# a_8780_247# a_13474_923.t5 PDACVSS.t40 sg13_hv_nmos ad=0.114p pd=0.98u as=0.204p ps=1.88u w=0.6u l=0.6u
X305 ODACOUT a_7384_3755# a_7280_4421# PDACVSS.t7 sg13_hv_nmos ad=0.34p pd=2.68u as=0.34p ps=2.68u w=1u l=0.45u
X306 a_10846_727# a_10180_247# PDACVSS.t169 PDACVSS.t31 sg13_hv_nmos ad=0.114p pd=0.98u as=0.204p ps=1.88u w=0.6u l=2.4u
X307 a_14228_5819# a_8700_4135# a_12014_1063# PDACVDD.t0 sg13_hv_pmos ad=0.228p pd=1.58u as=0.408p ps=3.08u w=1.2u l=0.6u
X308 PDACVDD.t27 PDACVDD.t25 PDACVDD.t26 PDACVDD.t0 sg13_hv_pmos ad=0.816p pd=5.48u as=0 ps=0 w=2.4u l=0.4u
X309 PDACVSS.t150 PDACVSS.t148 PDACVSS.t149 PDACVSS.t101 sg13_hv_nmos ad=0.408p pd=3.08u as=0 ps=0 w=1.2u l=0.6u
X310 a_10846_727# a_8780_247# a_10846_923# PDACVSS.t32 sg13_hv_nmos ad=0.114p pd=0.98u as=0.204p ps=1.88u w=0.6u l=0.6u
X311 ODACOUT.t32 a_13474_923.t17 PDACVSS.t263 PDACVSS.t227 sg13_hv_nmos ad=0.408p pd=3.08u as=0.408p ps=3.08u w=1.2u l=0.6u
X312 PDACVSS.t238 a_13474_923.t22 ODACOUT.t47 PDACVSS.t227 sg13_hv_nmos ad=0.408p pd=3.08u as=0.408p ps=3.08u w=1.2u l=0.6u
X313 a_10846_923# a_8780_247# a_10846_727# PDACVSS.t31 sg13_hv_nmos ad=0.204p pd=1.88u as=0.114p ps=0.98u w=0.6u l=0.6u
X314 a_11732_5295# a_8700_4135# a_11732_5491# PDACVDD.t0 sg13_hv_pmos ad=0.228p pd=1.58u as=0.408p ps=3.08u w=1.2u l=0.6u
X315 a_11732_5295# a_10714_5055# PDACVDD.t81 PDACVDD.t0 sg13_hv_pmos ad=0.228p pd=1.58u as=0.408p ps=3.08u w=1.2u l=1.2u
R0 a_13474_923.n6 a_13474_923.t12 17.3638
R1 a_13474_923.n1 a_13474_923.t16 5.64411
R2 a_13474_923.t14 a_13474_923.n4 5.64411
R3 a_13474_923.n8 a_13474_923.t4 17.0005
R4 a_13474_923.n9 a_13474_923.t5 17.0005
R5 a_13474_923.n7 a_13474_923.t6 17.0005
R6 a_13474_923.n6 a_13474_923.t7 17.0005
R7 a_13474_923.n8 a_13474_923.t8 17.0005
R8 a_13474_923.n9 a_13474_923.t9 17.0005
R9 a_13474_923.n7 a_13474_923.t10 17.0005
R10 a_13474_923.n6 a_13474_923.t11 17.0005
R11 a_13474_923.n0 a_13474_923.t15 5.64085
R12 a_13474_923.n3 a_13474_923.t13 5.64085
R13 a_13474_923.n13 a_13474_923.t17 15.4352
R14 a_13474_923.n11 a_13474_923.t24 15.4352
R15 a_13474_923.n14 a_13474_923.t19 15.0005
R16 a_13474_923.n13 a_13474_923.t18 15.0005
R17 a_13474_923.n17 a_13474_923.t21 15.0005
R18 a_13474_923.n16 a_13474_923.t20 15.0005
R19 a_13474_923.n11 a_13474_923.t23 15.0005
R20 a_13474_923.n12 a_13474_923.t22 15.0005
R21 a_13474_923.n1 a_13474_923.n0 0.0316692
R22 a_13474_923.n3 a_13474_923.n4 0.0316692
R23 a_13474_923.n19 a_13474_923.n18 6.19872
R24 a_13474_923.n5 a_13474_923.n10 4.84654
R25 a_13474_923.n19 a_13474_923.t2 3.52107
R26 a_13474_923.n19 a_13474_923.t1 3.51945
R27 a_13474_923.t0 a_13474_923.n20 2.43102
R28 a_13474_923.n20 a_13474_923.t3 2.43083
R29 a_13474_923.n18 a_13474_923.n5 0.6429
R30 a_13474_923.n14 a_13474_923.n13 0.435199
R31 a_13474_923.n17 a_13474_923.n16 0.435199
R32 a_13474_923.n12 a_13474_923.n11 0.435199
R33 a_13474_923.n9 a_13474_923.n8 0.196354
R34 a_13474_923.n7 a_13474_923.n6 0.196354
R35 a_13474_923.n20 a_13474_923.n19 0.169653
R36 a_13474_923.n15 a_13474_923.n0 0.134646
R37 a_13474_923.n3 a_13474_923.n2 0.134646
R38 a_13474_923.n15 a_13474_923.n14 0.109175
R39 a_13474_923.n16 a_13474_923.n15 0.109175
R40 a_13474_923.n2 a_13474_923.n17 0.109175
R41 a_13474_923.n2 a_13474_923.n12 0.109175
R42 a_13474_923.n10 a_13474_923.n9 0.0984268
R43 a_13474_923.n10 a_13474_923.n7 0.0984268
R44 a_13474_923.n4 a_13474_923.n18 4.56255
R45 a_13474_923.n1 a_13474_923.n5 4.56255
R46 a_12980_5491.n3 a_12980_5491.t6 5.65053
R47 a_12980_5491.n1 a_12980_5491.t17 15.3822
R48 a_12980_5491.n0 a_12980_5491.t24 15.3822
R49 a_12980_5491.n1 a_12980_5491.t19 15.0005
R50 a_12980_5491.n1 a_12980_5491.t18 15.0005
R51 a_12980_5491.n0 a_12980_5491.t21 15.0005
R52 a_12980_5491.n1 a_12980_5491.t20 15.0005
R53 a_12980_5491.n0 a_12980_5491.t23 15.0005
R54 a_12980_5491.n0 a_12980_5491.t22 15.0005
R55 a_12980_5491.n5 a_12980_5491.t4 13.5281
R56 a_12980_5491.n2 a_12980_5491.n5 10.6488
R57 a_12980_5491.t3 a_12980_5491.n1 2.46285
R58 a_12980_5491.t0 a_12980_5491.n0 2.46285
R59 a_12980_5491.n3 a_12980_5491.t7 5.64473
R60 a_12980_5491.t10 a_12980_5491.n3 5.64454
R61 a_12980_5491.n4 a_12980_5491.t13 6.53461
R62 a_12980_5491.n4 a_12980_5491.t16 6.53461
R63 a_12980_5491.n3 a_12980_5491.t11 6.12961
R64 a_12980_5491.n2 a_12980_5491.n3 6.06681
R65 a_12980_5491.n1 a_12980_5491.t2 2.40275
R66 a_12980_5491.t1 a_12980_5491.n0 2.40275
R67 a_12980_5491.n3 a_12980_5491.t8 5.66867
R68 a_12980_5491.n3 a_12980_5491.t9 5.66867
R69 a_12980_5491.n4 a_12980_5491.t14 5.66867
R70 a_12980_5491.n3 a_12980_5491.t5 5.66811
R71 a_12980_5491.n3 a_12980_5491.t12 5.66811
R72 a_12980_5491.n4 a_12980_5491.t15 5.66811
R73 a_12980_5491.n5 a_12980_5491.n4 5.18849
R74 a_12980_5491.n2 a_12980_5491.n0 2.1244
R75 a_12980_5491.n1 a_12980_5491.n0 1.8268
R76 ODACOUT.t28 ODACOUT.t23 2.33169
R77 ODACOUT.t19 ODACOUT.t23 2.37921
R78 ODACOUT.t13 ODACOUT.t23 2.37934
R79 ODACOUT.t6 ODACOUT.t23 2.3854
R80 ODACOUT.t23 ODACOUT.t17 2.36825
R81 ODACOUT.t23 ODACOUT.t9 2.36825
R82 ODACOUT.t15 ODACOUT.t4 2.37111
R83 ODACOUT.t20 ODACOUT.t4 2.37934
R84 ODACOUT.t22 ODACOUT.t4 2.37934
R85 ODACOUT.t7 ODACOUT.t4 2.40257
R86 ODACOUT.t4 ODACOUT.t14 2.36825
R87 ODACOUT.t4 ODACOUT.t16 2.36825
R88 ODACOUT.t12 ODACOUT.t10 2.37111
R89 ODACOUT.t3 ODACOUT.t10 2.37934
R90 ODACOUT.t11 ODACOUT.t10 2.37934
R91 ODACOUT.t26 ODACOUT.t10 2.40257
R92 ODACOUT.t10 ODACOUT.t30 2.36825
R93 ODACOUT.t10 ODACOUT.t29 2.36825
R94 ODACOUT.t25 ODACOUT.t5 2.40257
R95 ODACOUT.t2 ODACOUT.t5 2.40257
R96 ODACOUT.t8 ODACOUT.t5 2.40257
R97 ODACOUT.t24 ODACOUT.t5 2.37111
R98 ODACOUT.t5 ODACOUT.t21 2.37111
R99 ODACOUT.t5 ODACOUT.t27 2.37111
R100 ODACOUT.t55 ODACOUT.t35 5.64085
R101 ODACOUT.t35 ODACOUT.t49 5.64085
R102 ODACOUT.t32 ODACOUT.t50 5.64085
R103 ODACOUT.t39 ODACOUT.t35 5.63396
R104 ODACOUT.t32 ODACOUT.t40 5.63396
R105 ODACOUT.t32 ODACOUT.t31 5.63396
R106 ODACOUT.t48 ODACOUT.t46 5.64085
R107 ODACOUT.t46 ODACOUT.t33 5.64085
R108 ODACOUT.t46 ODACOUT.t34 5.64085
R109 ODACOUT.t37 ODACOUT.t46 5.63396
R110 ODACOUT.t46 ODACOUT.t38 5.63396
R111 ODACOUT.t46 ODACOUT.t58 5.63396
R112 ODACOUT.t56 ODACOUT.t47 5.64085
R113 ODACOUT.t47 ODACOUT.t53 5.64085
R114 ODACOUT.t47 ODACOUT.t54 5.64085
R115 ODACOUT.t44 ODACOUT.t47 5.63396
R116 ODACOUT.t47 ODACOUT.t45 5.63396
R117 ODACOUT.t47 ODACOUT.t57 5.63396
R118 ODACOUT.t41 ODACOUT.t36 5.64085
R119 ODACOUT.t36 ODACOUT.t59 5.64085
R120 ODACOUT.t36 ODACOUT.t42 5.64085
R121 ODACOUT.t51 ODACOUT.t36 5.63396
R122 ODACOUT.t36 ODACOUT.t52 5.63396
R123 ODACOUT.t36 ODACOUT.t43 5.63396
R124 ODACOUT.t18 ODACOUT.t0 2.43102
R125 ODACOUT.t35 ODACOUT.t4 1.90095
R126 ODACOUT.t35 ODACOUT.t36 1.42524
R127 ODACOUT.t35 ODACOUT.t47 1.42524
R128 ODACOUT.t35 ODACOUT.t46 1.42524
R129 ODACOUT.t10 ODACOUT.t35 1.25099
R130 ODACOUT.t35 ODACOUT.t23 0.648867
R131 ODACOUT.t35 ODACOUT.t5 0.644948
R132 ODACOUT.t23 ODACOUT.t18 1.21764
R133 ODACOUT.t35 ODACOUT.t32 1.10689
R134 ODACOUT.t5 ODACOUT.t1 1.07307
R135 ODACOUT ODACOUT.t35 1.0005
R136 PDACVDD.n8 PDACVDD.t5 17.444
R137 PDACVDD.t54 PDACVDD.t0 2.39402
R138 PDACVDD.t57 PDACVDD.t0 2.39358
R139 PDACVDD.t142 PDACVDD.t0 2.40951
R140 PDACVDD.t143 PDACVDD.t0 2.39291
R141 PDACVDD.t144 PDACVDD.t0 2.39615
R142 PDACVDD.t145 PDACVDD.t0 2.38605
R143 PDACVDD.t146 PDACVDD.t0 2.34807
R144 PDACVDD.t60 PDACVDD.t0 2.39984
R145 PDACVDD.t0 PDACVDD.t9 2.4151
R146 PDACVDD.t1 PDACVDD.t0 2.54075
R147 PDACVDD.t107 PDACVDD.t0 2.40511
R148 PDACVDD.t108 PDACVDD.t0 2.39291
R149 PDACVDD.t0 PDACVDD.t109 2.3943
R150 PDACVDD.t110 PDACVDD.t0 2.39984
R151 PDACVDD.t111 PDACVDD.t0 2.34615
R152 PDACVDD.t11 PDACVDD.t0 2.41018
R153 PDACVDD.t96 PDACVDD.t0 5.65327
R154 PDACVDD.t93 PDACVDD.t0 5.65327
R155 PDACVDD.t94 PDACVDD.t0 5.65327
R156 PDACVDD.t0 PDACVDD.t67 5.6492
R157 PDACVDD.t71 PDACVDD.t0 5.65807
R158 PDACVDD.t66 PDACVDD.t0 5.6492
R159 PDACVDD.t0 PDACVDD.t63 5.65318
R160 PDACVDD.t64 PDACVDD.t0 5.6492
R161 PDACVDD.t0 PDACVDD.t72 5.6492
R162 PDACVDD.t0 PDACVDD.t65 5.65512
R163 PDACVDD.t62 PDACVDD.t0 5.67942
R164 PDACVDD.t61 PDACVDD.t0 5.66271
R165 PDACVDD.t73 PDACVDD.t0 5.69581
R166 PDACVDD.t74 PDACVDD.t0 5.66012
R167 PDACVDD.t75 PDACVDD.t0 5.64151
R168 PDACVDD.t76 PDACVDD.t0 5.6492
R169 PDACVDD.t69 PDACVDD.t0 5.65945
R170 PDACVDD.t78 PDACVDD.t0 5.65782
R171 PDACVDD.t0 PDACVDD.t80 5.64563
R172 PDACVDD.t81 PDACVDD.t0 5.80886
R173 PDACVDD.t82 PDACVDD.t0 5.62336
R174 PDACVDD.t83 PDACVDD.t0 5.64563
R175 PDACVDD.t84 PDACVDD.t0 5.65266
R176 PDACVDD.t0 PDACVDD.t85 5.64563
R177 PDACVDD.t0 PDACVDD.t86 5.64564
R178 PDACVDD.t87 PDACVDD.t0 5.61267
R179 PDACVDD.t88 PDACVDD.t0 5.64569
R180 PDACVDD.t89 PDACVDD.t0 5.63066
R181 PDACVDD.t0 PDACVDD.t91 5.65964
R182 PDACVDD.t0 PDACVDD.t10 15.0005
R183 PDACVDD.t0 PDACVDD.t16 15.0005
R184 PDACVDD.t0 PDACVDD.t22 15.0005
R185 PDACVDD.t0 PDACVDD.t28 15.0005
R186 PDACVDD.t0 PDACVDD.t34 15.0005
R187 PDACVDD.t0 PDACVDD.t40 15.0005
R188 PDACVDD.t0 PDACVDD.t49 15.0005
R189 PDACVDD.t0 PDACVDD.t58 15.0005
R190 PDACVDD.t0 PDACVDD.t37 15.0005
R191 PDACVDD.t0 PDACVDD.t43 15.0005
R192 PDACVDD.t0 PDACVDD.t52 15.0005
R193 PDACVDD.t0 PDACVDD.t7 15.0005
R194 PDACVDD.t0 PDACVDD.t13 15.0005
R195 PDACVDD.t0 PDACVDD.t19 15.0005
R196 PDACVDD.t0 PDACVDD.t25 15.0005
R197 PDACVDD.t0 PDACVDD.t31 15.0005
R198 PDACVDD.t113 PDACVDD.n11 2.37111
R199 PDACVDD.t114 PDACVDD.n11 2.37111
R200 PDACVDD.t115 PDACVDD.t0 2.37111
R201 PDACVDD.t116 PDACVDD.t0 2.37111
R202 PDACVDD.t17 PDACVDD.t0 2.37111
R203 PDACVDD.t118 PDACVDD.n11 2.40257
R204 PDACVDD.t119 PDACVDD.t0 2.40257
R205 PDACVDD.t120 PDACVDD.t0 2.40257
R206 PDACVDD.t121 PDACVDD.t0 2.40257
R207 PDACVDD.t23 PDACVDD.t0 2.40257
R208 PDACVDD.n10 PDACVDD.t123 2.37111
R209 PDACVDD.n10 PDACVDD.t124 2.37111
R210 PDACVDD.n13 PDACVDD.t125 2.37111
R211 PDACVDD.n13 PDACVDD.t126 2.37111
R212 PDACVDD.t0 PDACVDD.t29 2.35294
R213 PDACVDD.n10 PDACVDD.t128 2.40257
R214 PDACVDD.n13 PDACVDD.t129 2.40257
R215 PDACVDD.n13 PDACVDD.t130 2.40257
R216 PDACVDD.t0 PDACVDD.t131 2.40257
R217 PDACVDD.t0 PDACVDD.t35 2.37762
R218 PDACVDD.n9 PDACVDD.t133 2.37111
R219 PDACVDD.n9 PDACVDD.t134 2.37111
R220 PDACVDD.n12 PDACVDD.t135 2.37111
R221 PDACVDD.n12 PDACVDD.t136 2.37111
R222 PDACVDD.n12 PDACVDD.t41 2.3614
R223 PDACVDD.n9 PDACVDD.t138 2.40257
R224 PDACVDD.n12 PDACVDD.t139 2.40257
R225 PDACVDD.n12 PDACVDD.t140 2.40257
R226 PDACVDD.n12 PDACVDD.t141 2.40257
R227 PDACVDD.t0 PDACVDD.t50 2.36029
R228 PDACVDD.n1 PDACVDD.t79 6.59637
R229 PDACVDD.n0 PDACVDD.t104 6.59637
R230 PDACVDD.n7 PDACVDD.t105 6.59559
R231 PDACVDD.n2 PDACVDD.t90 6.59559
R232 PDACVDD.t0 PDACVDD.t98 6.35323
R233 PDACVDD.t0 PDACVDD.t68 6.35323
R234 PDACVDD.t0 PDACVDD.t77 6.2153
R235 PDACVDD.t0 PDACVDD.t100 6.2153
R236 PDACVDD.t0 PDACVDD.t3 5.89181
R237 PDACVDD.t0 PDACVDD.t2 5.89181
R238 PDACVDD.n8 PDACVDD.t95 5.86126
R239 PDACVDD.t0 PDACVDD.t97 5.68217
R240 PDACVDD.n1 PDACVDD.t70 5.53294
R241 PDACVDD.n0 PDACVDD.t102 5.53294
R242 PDACVDD.n7 PDACVDD.t106 5.53294
R243 PDACVDD.n2 PDACVDD.t92 5.53294
R244 PDACVDD.n5 PDACVDD.t56 4.59423
R245 PDACVDD.n4 PDACVDD.t47 4.59423
R246 PDACVDD.n3 PDACVDD.t48 4.59423
R247 PDACVDD.t0 PDACVDD.t32 2.95874
R248 PDACVDD.t0 PDACVDD.t33 2.95874
R249 PDACVDD.t0 PDACVDD.t26 2.95874
R250 PDACVDD.t0 PDACVDD.t27 2.95874
R251 PDACVDD.t0 PDACVDD.t20 2.95874
R252 PDACVDD.t0 PDACVDD.t21 2.95874
R253 PDACVDD.t0 PDACVDD.t14 2.95874
R254 PDACVDD.t0 PDACVDD.t15 2.95874
R255 PDACVDD.t0 PDACVDD.t8 2.95874
R256 PDACVDD.t0 PDACVDD.t38 2.95874
R257 PDACVDD.t0 PDACVDD.t39 2.95874
R258 PDACVDD.t0 PDACVDD.t12 2.95665
R259 PDACVDD.t0 PDACVDD.t18 2.95665
R260 PDACVDD.t0 PDACVDD.t24 2.95665
R261 PDACVDD.t0 PDACVDD.t30 2.95665
R262 PDACVDD.t0 PDACVDD.t36 2.95665
R263 PDACVDD.t0 PDACVDD.t42 2.95665
R264 PDACVDD.t0 PDACVDD.t51 2.95665
R265 PDACVDD.t0 PDACVDD.t59 2.95537
R266 PDACVDD.n11 PDACVDD.t117 2.43102
R267 PDACVDD.n10 PDACVDD.t127 2.43102
R268 PDACVDD.n9 PDACVDD.t137 2.43102
R269 PDACVDD.n11 PDACVDD.t112 2.43083
R270 PDACVDD.n10 PDACVDD.t122 2.43083
R271 PDACVDD.n9 PDACVDD.t132 2.43083
R272 PDACVDD.n5 PDACVDD.t53 2.17524
R273 PDACVDD.n4 PDACVDD.t44 2.17524
R274 PDACVDD.n3 PDACVDD.t45 2.17524
R275 PDACVDD.n11 PDACVDD.n6 0.677551
R276 PDACVDD.t0 PDACVDD.n2 1.67312
R277 PDACVDD.t0 PDACVDD.n7 1.58658
R278 PDACVDD.n14 PDACVDD.n6 0.349277
R279 PDACVDD.n14 PDACVDD.n9 1.5005
R280 PDACVDD.n14 PDACVDD.n10 1.5005
R281 PDACVDD.t0 PDACVDD.n6 0.253975
R282 PDACVDD.n10 PDACVDD.n13 1.42145
R283 PDACVDD.n9 PDACVDD.n12 1.42145
R284 PDACVDD.n8 PDACVDD.t0 1.17135
R285 PDACVDD.n12 PDACVDD.t0 1.1077
R286 PDACVDD.t0 PDACVDD.n1 0.820787
R287 PDACVDD.t0 PDACVDD.n0 0.820787
R288 PDACVDD.t0 PDACVDD.n5 0.783998
R289 PDACVDD.t0 PDACVDD.n4 0.783998
R290 PDACVDD.t0 PDACVDD.n3 0.783998
R291 PDACVDD.n13 PDACVDD.t0 1.01113
R292 PDACVSS.t7 PDACVSS.n43 49.3221
R293 PDACVSS.n6 PDACVSS.n0 0.109793
R294 PDACVSS.t22 PDACVSS.n34 13.7836
R295 PDACVSS.t57 PDACVSS.n6 13.9905
R296 PDACVSS.n18 PDACVSS.t210 43.8882
R297 PDACVSS.n35 PDACVSS.t26 15.6863
R298 PDACVSS.t25 PDACVSS.n35 38.4215
R299 PDACVSS.n26 PDACVSS.t8 7.08555
R300 PDACVSS.n41 PDACVSS.t25 44.5992
R301 PDACVSS.n11 PDACVSS.t34 6.43275
R302 PDACVSS.n20 PDACVSS.t31 30.5458
R303 PDACVSS.n26 PDACVSS.t47 9.05199
R304 PDACVSS.n26 PDACVSS.t192 9.04338
R305 PDACVSS.t39 PDACVSS.t15 24.9312
R306 PDACVSS.t42 PDACVSS.n17 11.2745
R307 PDACVSS.t175 PDACVSS.n26 9.79589
R308 PDACVSS.t63 PDACVSS.n9 18.7303
R309 PDACVSS.t35 PDACVSS.n6 10.1107
R310 PDACVSS.n26 PDACVSS.t199 10.3979
R311 PDACVSS.n21 PDACVSS.t227 6.68027
R312 PDACVSS.t14 PDACVSS.n10 22.7904
R313 PDACVSS.n35 PDACVSS.n34 0.395068
R314 PDACVSS.n34 PDACVSS.n27 0.616613
R315 PDACVSS.n6 PDACVSS.t44 17.6536
R316 PDACVSS.n6 PDACVSS.t45 17.6536
R317 PDACVSS.n6 PDACVSS.t58 17.633
R318 PDACVSS.n6 PDACVSS.t59 17.4955
R319 PDACVSS.n12 PDACVSS.t33 13.4558
R320 PDACVSS.n7 PDACVSS.n6 0.271281
R321 PDACVSS.n6 PDACVSS.n17 0.00367923
R322 PDACVSS.n6 PDACVSS.t61 17.3488
R323 PDACVSS.n58 PDACVSS.t20 17.2842
R324 PDACVSS.n61 PDACVSS.t29 17.1243
R325 PDACVSS.n59 PDACVSS.t18 17.1243
R326 PDACVSS.n57 PDACVSS.t56 17.123
R327 PDACVSS.n26 PDACVSS.t23 17.0912
R328 PDACVSS.n6 PDACVSS.t103 5.59546
R329 PDACVSS.t106 PDACVSS.n21 5.64519
R330 PDACVSS.t220 PDACVSS.n21 5.64519
R331 PDACVSS.t222 PDACVSS.n21 5.64519
R332 PDACVSS.t224 PDACVSS.n21 5.64519
R333 PDACVSS.n21 PDACVSS.t226 5.59546
R334 PDACVSS.t228 PDACVSS.n21 5.64519
R335 PDACVSS.t109 PDACVSS.n21 5.64519
R336 PDACVSS.n6 PDACVSS.n13 0.748564
R337 PDACVSS.t41 PDACVSS.n13 9.89225
R338 PDACVSS.n7 PDACVSS.t37 5.41173
R339 PDACVSS.n6 PDACVSS.n10 2.39758
R340 PDACVSS.n9 PDACVSS.t46 4.13194
R341 PDACVSS.n11 PDACVSS.t63 20.9887
R342 PDACVSS.n6 PDACVSS.n12 0.129772
R343 PDACVSS.n6 PDACVSS.n19 0.030313
R344 PDACVSS.n19 PDACVSS.t215 46.3353
R345 PDACVSS.n16 PDACVSS.t31 14.8985
R346 PDACVSS.n20 PDACVSS.t208 36.5885
R347 PDACVSS.n6 PDACVSS.t30 17.0005
R348 PDACVSS.n6 PDACVSS.n39 0.620913
R349 PDACVSS.n41 PDACVSS.n34 0.489132
R350 PDACVSS.t24 PDACVSS.n41 16.4537
R351 PDACVSS.t16 PDACVSS.n34 6.5311
R352 PDACVSS.n26 PDACVSS.t17 17.0005
R353 PDACVSS.n17 PDACVSS.t73 43.4405
R354 PDACVSS.n0 PDACVSS.t39 17.0896
R355 PDACVSS.n6 PDACVSS.n8 0.00133504
R356 PDACVSS.t15 PDACVSS.n8 10.9559
R357 PDACVSS.t36 PDACVSS.n10 4.2649
R358 PDACVSS.n6 PDACVSS.n9 1.49799
R359 PDACVSS.n23 PDACVSS.n6 0.240207
R360 PDACVSS.n12 PDACVSS.t210 12.9948
R361 PDACVSS.n6 PDACVSS.n18 0.210611
R362 PDACVSS.n6 PDACVSS.n49 8.4999
R363 PDACVSS.n6 PDACVSS.n16 0.372174
R364 PDACVSS.n6 PDACVSS.n20 2.19828
R365 PDACVSS.n6 PDACVSS.n15 0.00174999
R366 PDACVSS.t156 PDACVSS.n6 5.6143
R367 PDACVSS.n21 PDACVSS.t204 5.65569
R368 PDACVSS.t259 PDACVSS.n21 5.64762
R369 PDACVSS.t260 PDACVSS.n21 5.64762
R370 PDACVSS.t261 PDACVSS.n21 5.65658
R371 PDACVSS.n21 PDACVSS.t262 5.60328
R372 PDACVSS.t263 PDACVSS.n21 5.64762
R373 PDACVSS.t159 PDACVSS.n21 5.64762
R374 PDACVSS.n6 PDACVSS.t163 17.0005
R375 PDACVSS.n6 PDACVSS.t168 17.0005
R376 PDACVSS.n30 PDACVSS.t169 17.0005
R377 PDACVSS.n30 PDACVSS.t170 17.0005
R378 PDACVSS.n30 PDACVSS.t171 17.0005
R379 PDACVSS.n30 PDACVSS.t172 17.0005
R380 PDACVSS.n30 PDACVSS.t173 17.0005
R381 PDACVSS.n30 PDACVSS.t184 17.0005
R382 PDACVSS.n30 PDACVSS.t185 17.0005
R383 PDACVSS.n30 PDACVSS.t186 17.0005
R384 PDACVSS.n30 PDACVSS.t187 17.0005
R385 PDACVSS.n46 PDACVSS.t188 17.0005
R386 PDACVSS.n46 PDACVSS.t189 17.0005
R387 PDACVSS.n51 PDACVSS.t190 17.0005
R388 PDACVSS.n6 PDACVSS.t123 17.0005
R389 PDACVSS.t118 PDACVSS.n21 5.64762
R390 PDACVSS.n21 PDACVSS.t128 5.57386
R391 PDACVSS.t134 PDACVSS.n21 5.64762
R392 PDACVSS.t146 PDACVSS.n21 5.64762
R393 PDACVSS.n6 PDACVSS.t206 17.0005
R394 PDACVSS.n6 PDACVSS.t209 17.0005
R395 PDACVSS.n6 PDACVSS.t216 17.0005
R396 PDACVSS.n6 PDACVSS.t214 17.0005
R397 PDACVSS.n6 PDACVSS.t211 17.0005
R398 PDACVSS.n6 PDACVSS.t161 17.0005
R399 PDACVSS.n6 PDACVSS.t164 17.0005
R400 PDACVSS.n6 PDACVSS.t165 17.0005
R401 PDACVSS.n6 PDACVSS.t166 17.0005
R402 PDACVSS.n6 PDACVSS.t167 17.0005
R403 PDACVSS.t65 PDACVSS.n6 5.64018
R404 PDACVSS.t68 PDACVSS.n23 2.46543
R405 PDACVSS.t71 PDACVSS.n6 2.38515
R406 PDACVSS.t75 PDACVSS.n6 5.64018
R407 PDACVSS.t90 PDACVSS.n6 5.63705
R408 PDACVSS.t93 PDACVSS.n6 2.40156
R409 PDACVSS.t96 PDACVSS.n6 2.417
R410 PDACVSS.n6 PDACVSS.t99 5.65339
R411 PDACVSS.n6 PDACVSS.t162 17.0005
R412 PDACVSS.n6 PDACVSS.t176 17.0005
R413 PDACVSS.n6 PDACVSS.t177 17.0005
R414 PDACVSS.n6 PDACVSS.t178 17.0005
R415 PDACVSS.n6 PDACVSS.t179 17.0005
R416 PDACVSS.n6 PDACVSS.t180 17.0005
R417 PDACVSS.n6 PDACVSS.t181 17.0005
R418 PDACVSS.n6 PDACVSS.t182 17.0005
R419 PDACVSS.n6 PDACVSS.t183 17.0005
R420 PDACVSS.n6 PDACVSS.t121 17.0005
R421 PDACVSS.n6 PDACVSS.t160 17.0005
R422 PDACVSS.n6 PDACVSS.t212 17.0005
R423 PDACVSS.n43 PDACVSS.t200 7.29451
R424 PDACVSS.n43 PDACVSS.n26 1.34316
R425 PDACVSS.n44 PDACVSS.n26 0.176891
R426 PDACVSS.t7 PDACVSS.n44 12.9853
R427 PDACVSS.n26 PDACVSS.n29 0.121664
R428 PDACVSS.n28 PDACVSS.t12 11.2798
R429 PDACVSS.t217 PDACVSS.n26 9.79587
R430 PDACVSS.n26 PDACVSS.t5 11.2932
R431 PDACVSS.n26 PDACVSS.t10 10.3982
R432 PDACVSS.n26 PDACVSS.t174 7.08436
R433 PDACVSS.n26 PDACVSS.t198 9.30235
R434 PDACVSS.n26 PDACVSS.t194 10.8401
R435 PDACVSS.n26 PDACVSS.t11 10.84
R436 PDACVSS.n39 PDACVSS.t60 17.0005
R437 PDACVSS.n58 PDACVSS.t21 17.0005
R438 PDACVSS.t193 PDACVSS.n26 11.2931
R439 PDACVSS.n32 PDACVSS.t53 8.00535
R440 PDACVSS.t218 PDACVSS.n26 5.8488
R441 PDACVSS.t208 PDACVSS.n15 9.22393
R442 PDACVSS.t38 PDACVSS.n8 12.6143
R443 PDACVSS.n47 PDACVSS.t202 15.2083
R444 PDACVSS.n48 PDACVSS.t203 15.1484
R445 PDACVSS.n26 PDACVSS.t9 15.21
R446 PDACVSS.n21 PDACVSS.t107 15.0005
R447 PDACVSS.n21 PDACVSS.t117 15.0005
R448 PDACVSS.n21 PDACVSS.t127 15.0005
R449 PDACVSS.n21 PDACVSS.t133 15.0005
R450 PDACVSS.n21 PDACVSS.t139 15.0005
R451 PDACVSS.n21 PDACVSS.t145 15.0005
R452 PDACVSS.n21 PDACVSS.t151 15.0005
R453 PDACVSS.n21 PDACVSS.t157 15.0005
R454 PDACVSS.n6 PDACVSS.t100 15.0005
R455 PDACVSS.n6 PDACVSS.t111 15.0005
R456 PDACVSS.n6 PDACVSS.t124 15.0005
R457 PDACVSS.n6 PDACVSS.t130 15.0005
R458 PDACVSS.n6 PDACVSS.t136 15.0005
R459 PDACVSS.n6 PDACVSS.t142 15.0005
R460 PDACVSS.n6 PDACVSS.t148 15.0005
R461 PDACVSS.n6 PDACVSS.t154 15.0005
R462 PDACVSS.n6 PDACVSS.t82 15.0005
R463 PDACVSS.n6 PDACVSS.t88 15.0005
R464 PDACVSS.n6 PDACVSS.t62 15.0005
R465 PDACVSS.n6 PDACVSS.t76 15.0005
R466 PDACVSS.n6 PDACVSS.t72 15.0005
R467 PDACVSS.n6 PDACVSS.t79 15.0005
R468 PDACVSS.n6 PDACVSS.t85 15.0005
R469 PDACVSS.n6 PDACVSS.t97 15.0005
R470 PDACVSS.n6 PDACVSS.t91 15.0005
R471 PDACVSS.n54 PDACVSS.t66 15.0005
R472 PDACVSS.n40 PDACVSS.t48 15.0005
R473 PDACVSS.n47 PDACVSS.t197 15.0005
R474 PDACVSS.n29 PDACVSS.t0 10.8013
R475 PDACVSS.n15 PDACVSS.t19 16.9753
R476 PDACVSS.n28 PDACVSS.t52 11.4342
R477 PDACVSS.n21 PDACVSS.t221 16.5078
R478 PDACVSS.n21 PDACVSS.t223 16.4919
R479 PDACVSS.n21 PDACVSS.t225 12.9257
R480 PDACVSS.n21 PDACVSS.t108 12.9221
R481 PDACVSS.t43 PDACVSS.n6 13.6114
R482 PDACVSS.n42 PDACVSS.n26 9.8344
R483 PDACVSS.t201 PDACVSS.n44 8.43292
R484 PDACVSS.t195 PDACVSS.n42 2.17743
R485 PDACVSS.t215 PDACVSS.n16 16.5123
R486 PDACVSS.t101 PDACVSS.n21 12.9258
R487 PDACVSS.t55 PDACVSS.n42 5.30628
R488 PDACVSS.n26 PDACVSS.n45 0.25019
R489 PDACVSS.n25 PDACVSS.t230 5.64085
R490 PDACVSS.n25 PDACVSS.t231 5.64085
R491 PDACVSS.n25 PDACVSS.t232 5.64085
R492 PDACVSS.n25 PDACVSS.t233 5.64085
R493 PDACVSS.n25 PDACVSS.t235 5.63396
R494 PDACVSS.n25 PDACVSS.t236 5.63396
R495 PDACVSS.n25 PDACVSS.t237 5.63396
R496 PDACVSS.n25 PDACVSS.t238 5.63396
R497 PDACVSS.n37 PDACVSS.t240 5.64085
R498 PDACVSS.n37 PDACVSS.t241 5.64085
R499 PDACVSS.n21 PDACVSS.t242 5.64085
R500 PDACVSS.n21 PDACVSS.t243 5.64085
R501 PDACVSS.n37 PDACVSS.t245 5.63396
R502 PDACVSS.n21 PDACVSS.t246 5.63396
R503 PDACVSS.n21 PDACVSS.t247 5.63396
R504 PDACVSS.n21 PDACVSS.t248 5.63396
R505 PDACVSS.n21 PDACVSS.t140 5.61401
R506 PDACVSS.n38 PDACVSS.t250 5.64085
R507 PDACVSS.n38 PDACVSS.t251 5.64085
R508 PDACVSS.n21 PDACVSS.t252 5.64085
R509 PDACVSS.n21 PDACVSS.t253 5.64085
R510 PDACVSS.n38 PDACVSS.t255 5.63396
R511 PDACVSS.n21 PDACVSS.t256 5.63396
R512 PDACVSS.n21 PDACVSS.t257 5.63396
R513 PDACVSS.n21 PDACVSS.t258 5.63396
R514 PDACVSS.n21 PDACVSS.t152 5.64978
R515 PDACVSS.n6 PDACVSS.n11 0.00134575
R516 PDACVSS.n26 PDACVSS.t54 11.1498
R517 PDACVSS.n26 PDACVSS.t13 8.13216
R518 PDACVSS.t4 PDACVSS.n32 6.46158
R519 PDACVSS.t50 PDACVSS.n26 11.1423
R520 PDACVSS.t51 PDACVSS.n26 8.13163
R521 PDACVSS.n26 PDACVSS.t2 9.79641
R522 PDACVSS.n29 PDACVSS.t6 9.88125
R523 PDACVSS.n4 PDACVSS.t115 7.20137
R524 PDACVSS.n5 PDACVSS.t116 7.20137
R525 PDACVSS.n3 PDACVSS.t105 7.20137
R526 PDACVSS.t27 PDACVSS.n34 10.6986
R527 PDACVSS.t28 PDACVSS.n34 10.8666
R528 PDACVSS.n24 PDACVSS.n6 0.325376
R529 PDACVSS.n50 PDACVSS.n46 6.0005
R530 PDACVSS.n6 PDACVSS.t155 5.94073
R531 PDACVSS.n6 PDACVSS.t149 5.94073
R532 PDACVSS.n6 PDACVSS.t150 5.94073
R533 PDACVSS.n6 PDACVSS.t143 5.94073
R534 PDACVSS.n6 PDACVSS.t144 5.94073
R535 PDACVSS.n6 PDACVSS.t137 5.94073
R536 PDACVSS.n6 PDACVSS.t138 5.94073
R537 PDACVSS.n6 PDACVSS.t131 5.94073
R538 PDACVSS.n6 PDACVSS.t132 5.94073
R539 PDACVSS.n6 PDACVSS.t125 5.94073
R540 PDACVSS.n6 PDACVSS.t126 5.94073
R541 PDACVSS.n21 PDACVSS.t110 5.9403
R542 PDACVSS.n21 PDACVSS.t119 5.9403
R543 PDACVSS.n21 PDACVSS.t129 5.9403
R544 PDACVSS.n21 PDACVSS.t135 5.9403
R545 PDACVSS.n21 PDACVSS.t141 5.9403
R546 PDACVSS.n21 PDACVSS.t147 5.9403
R547 PDACVSS.n21 PDACVSS.t153 5.9403
R548 PDACVSS.n21 PDACVSS.t158 5.9393
R549 PDACVSS.n6 PDACVSS.t77 5.88045
R550 PDACVSS.n6 PDACVSS.t83 5.88045
R551 PDACVSS.n6 PDACVSS.t84 5.88045
R552 PDACVSS.n6 PDACVSS.t78 5.88045
R553 PDACVSS.n6 PDACVSS.t80 5.88001
R554 PDACVSS.n6 PDACVSS.t81 5.88001
R555 PDACVSS.n6 PDACVSS.t86 5.88001
R556 PDACVSS.n6 PDACVSS.t87 5.88001
R557 PDACVSS.n25 PDACVSS.t234 5.66867
R558 PDACVSS.n37 PDACVSS.t244 5.66867
R559 PDACVSS.n38 PDACVSS.t254 5.66867
R560 PDACVSS.n25 PDACVSS.t229 5.66811
R561 PDACVSS.n37 PDACVSS.t239 5.66811
R562 PDACVSS.n38 PDACVSS.t249 5.66811
R563 PDACVSS.n2 PDACVSS.t89 5.76015
R564 PDACVSS.n1 PDACVSS.t74 5.59521
R565 PDACVSS.n52 PDACVSS.t64 5.59521
R566 PDACVSS.n4 PDACVSS.t112 5.53294
R567 PDACVSS.n5 PDACVSS.t113 5.53294
R568 PDACVSS.n3 PDACVSS.t102 5.53294
R569 PDACVSS.n26 PDACVSS.t1 10.8493
R570 PDACVSS.n6 PDACVSS.n36 0.332347
R571 PDACVSS.n6 PDACVSS.n30 0.126136
R572 PDACVSS.n34 PDACVSS.n14 0.100144
R573 PDACVSS.n18 PDACVSS.t32 49.9319
R574 PDACVSS.n0 PDACVSS.t40 5.95273
R575 PDACVSS.t73 PDACVSS.n13 8.69522
R576 PDACVSS.n26 PDACVSS.n32 0.188909
R577 PDACVSS.n26 PDACVSS.t3 8.11998
R578 PDACVSS.n46 PDACVSS.n51 0.108669
R579 PDACVSS.t219 PDACVSS.n21 12.9257
R580 PDACVSS.t104 PDACVSS.n21 6.67956
R581 PDACVSS.n6 PDACVSS.t122 3.04966
R582 PDACVSS.n6 PDACVSS.t120 3.03359
R583 PDACVSS.n49 PDACVSS.t213 3.02241
R584 PDACVSS.n31 PDACVSS.n30 1.92418
R585 PDACVSS.n26 PDACVSS.n48 0.620975
R586 PDACVSS.n2 PDACVSS.t92 2.64689
R587 PDACVSS.n56 PDACVSS.t70 2.28882
R588 PDACVSS.n53 PDACVSS.t67 2.28882
R589 PDACVSS.n49 PDACVSS.t32 2.26693
R590 PDACVSS.n22 PDACVSS.n38 0.411844
R591 PDACVSS.n62 PDACVSS.n37 1.5005
R592 PDACVSS.n53 PDACVSS.n52 1.23312
R593 PDACVSS.n6 PDACVSS.t95 2.64693
R594 PDACVSS.n1 PDACVSS.n56 1.2323
R595 PDACVSS.n60 PDACVSS.n34 1.13275
R596 PDACVSS.n47 PDACVSS.n26 0.169602
R597 PDACVSS.t19 PDACVSS.t205 0.784404
R598 PDACVSS.n6 PDACVSS.t207 17.4736
R599 PDACVSS.t213 PDACVSS.n19 8.03741
R600 PDACVSS.n39 PDACVSS.n58 0.670632
R601 PDACVSS.n56 PDACVSS.n55 0.621207
R602 PDACVSS.n6 PDACVSS.n2 0.0837438
R603 PDACVSS.n55 PDACVSS.n53 0.620732
R604 PDACVSS.n60 PDACVSS.n59 0.598075
R605 PDACVSS.n61 PDACVSS.n60 0.513169
R606 PDACVSS.n6 PDACVSS.n4 0.408287
R607 PDACVSS.n6 PDACVSS.n5 0.408287
R608 PDACVSS.n6 PDACVSS.n3 0.408287
R609 PDACVSS.n24 PDACVSS.n31 1.69422
R610 PDACVSS.n31 PDACVSS.n50 0.467073
R611 PDACVSS.n21 PDACVSS.n50 1.3622
R612 PDACVSS.n6 PDACVSS.t98 5.76024
R613 PDACVSS.n6 PDACVSS.n1 0.28608
R614 PDACVSS.n52 PDACVSS.n6 0.285738
R615 PDACVSS.n22 PDACVSS.n62 0.849904
R616 PDACVSS.n62 PDACVSS.n33 0.892821
R617 PDACVSS.n59 PDACVSS.n27 0.613367
R618 PDACVSS.n57 PDACVSS.n48 0.324163
R619 PDACVSS.n24 PDACVSS.n26 0.229855
R620 PDACVSS.n14 PDACVSS.n61 0.978715
R621 PDACVSS.n27 PDACVSS.n26 0.592706
R622 PDACVSS.n40 PDACVSS.n26 0.0789832
R623 PDACVSS.n55 PDACVSS.n54 0.0835
R624 PDACVSS.n36 PDACVSS.n51 0.143341
R625 PDACVSS.n45 PDACVSS.n57 0.146958
R626 PDACVSS.n36 PDACVSS.t191 17.0063
R627 PDACVSS.n54 PDACVSS.n23 0.202118
R628 PDACVSS.n45 PDACVSS.t196 15.0089
R629 PDACVSS.t49 PDACVSS.n40 15.2512
R630 PDACVSS.n25 PDACVSS.n33 1.23325
R631 PDACVSS.n22 PDACVSS.n21 0.484587
R632 PDACVSS.n37 PDACVSS.n21 1.23232
R633 PDACVSS.n21 PDACVSS.n6 1.12849
R634 PDACVSS.n6 PDACVSS.n14 0.11347
R635 PDACVSS.n30 PDACVSS.n46 1.00203
R636 PDACVSS.n26 PDACVSS.n28 0.946643
R637 PDACVSS.n33 PDACVSS.n21 0.91347
R638 PDACVSS.n7 PDACVSS.t14 21.452
C0 a_12306_727# a_13474_727# 0.01629f
C1 nD1 a_2314_288# 0.05869f
C2 a_8780_247# a_10554_727# 0.0161f
C3 nD0 a_1258_3288# 0.06299f
C4 a_10262_923# a_12463_2551# 0.14159f
C5 a_12014_923# a_10180_247# 0.03051f
C6 w_7156_4139# a_7280_4421# 0.08431f
C7 a_9008_4067# a_8700_4135# 1.59047f
C8 op_amp_ver_2_0.IOAM IDACDISABLE 0.09147f
C9 a_6010_3288# a_6010_288# 0.52308f
C10 a_10846_923# op_amp_ver_2_0.IOAM 0.62302f
C11 op_amp_ver_2_0.IOAM a_6802_3288# 0.9456f
C12 a_11732_5491# IDACDISABLE 0.29628f
C13 a_10262_923# IDACIREF 0.80712f
C14 a_7066_288# a_7330_288# 0.69758f
C15 a_730_3288# a_994_288# 0.11822f
C16 a_10846_727# a_10180_247# 0.90039f
C17 a_9272_2247# IDACDISABLE 0.03388f
C18 a_10846_923# a_11732_5491# 0.40288f
C19 a_5746_3288# a_6010_3288# 0.98837f
C20 a_11732_5295# a_10180_247# 0.59513f
C21 a_12463_2551# a_14228_5819# 0.02193f
C22 IDACVTAP op_amp_ver_2_0.IOAM 0.49163f
C23 a_4426_3288# a_4426_288# 0.52308f
C24 a_9008_4067# ODACOUT 0.04296f
C25 a_10180_247# a_8780_247# 3.72344f
C26 a_11732_5491# a_12014_1063# 0.57059f
C27 IDACDISABLE a_7384_3755# 0.35832f
C28 a_4954_3288# a_5218_3288# 0.98837f
C29 a_1786_3288# a_2578_3288# 0.18525f
C30 a_2050_3288# a_2050_288# 0.52308f
C31 a_9120_2247# a_8780_247# 0.77912f
C32 op_amp_ver_2_0.IOAM a_10714_5055# 0.01209f
C33 a_5482_288# a_5746_3288# 0.08008f
C34 a_2578_3288# a_3370_288# 0.03164f
C35 a_11732_5491# a_10714_5055# 0.09253f
C36 a_3106_288# a_3370_288# 0.69758f
C37 w_7156_4139# ODACOUT 0.08121f
C38 a_3634_288# a_3898_288# 0.69758f
C39 a_4426_3288# nD4 0.06299f
C40 a_3634_3288# a_4162_3288# 0.32735f
C41 a_7280_4421# ODACOUT 0.41845f
C42 a_7594_388# a_7858_388# 0.65107f
C43 a_202_288# a_466_288# 0.69758f
C44 a_9008_4067# a_9280_4067# 1.11545f
C45 a_13474_727# IDACDISABLE 0.04695f
C46 a_5746_3288# nD5 0.06299f
C47 a_10262_923# IDACDISABLE 2.31907f
C48 ODACOUT a_8700_4135# 0.32919f
C49 nD1 a_2050_3288# 0.06299f
C50 a_12306_727# a_12014_923# 0.01099f
C51 a_4162_288# a_3370_3288# 0.03164f
C52 a_12014_1063# a_13474_727# 0.27219f
C53 a_12014_923# a_12463_2551# 0.08025f
C54 a_994_3288# a_1786_288# 0.03164f
C55 nD4 nD5 0.0239f
C56 a_6274_288# a_6538_288# 0.69758f
C57 a_10262_923# a_10714_5055# 0.16437f
C58 a_6802_288# a_7066_288# 0.69758f
C59 a_6802_3288# a_7330_288# 0.03523f
C60 a_11732_5491# op_amp_ver_2_0.IOAM 0.02854f
C61 a_5482_288# a_5746_288# 0.69758f
C62 a_11732_5295# a_12463_2551# 2.09149f
C63 a_12306_727# a_8780_247# 0.39887f
C64 a_9272_2247# op_amp_ver_2_0.IOAM 0.02585f
C65 a_14228_5819# a_12014_1063# 0.07035f
C66 a_11732_5295# a_11420_5295# 0.02193f
C67 a_9280_4067# a_8700_4135# 1.42543f
C68 a_1258_3288# a_1522_288# 0.26732f
C69 a_4690_288# a_4954_288# 0.69758f
C70 a_8780_247# a_11420_5295# 0.09967f
C71 a_1786_3288# a_2050_288# 0.08219f
C72 a_5218_288# a_5482_288# 0.69758f
C73 a_5218_3288# a_5746_3288# 0.32735f
C74 a_2578_3288# a_3106_288# 0.0115f
C75 a_14228_5819# a_10714_5055# 0.03571f
C76 a_10180_247# a_8700_4135# 0.06825f
C77 a_11420_5819# a_11732_5295# 0.02411f
C78 a_4954_288# a_4162_3288# 0.03164f
C79 a_7594_388# a_6802_3288# 0.01139f
C80 a_994_288# a_1258_288# 0.69758f
C81 a_8780_247# IDACIREF 0.11176f
C82 a_3370_3288# a_4162_3288# 0.18525f
C83 a_3634_3288# a_3634_288# 0.52308f
C84 a_9280_4067# ODACOUT 0.04384f
C85 a_15859_6052# a_12014_923# 0.38061f
C86 a_11420_5819# a_11108_5819# 0.01923f
C87 a_10180_247# ODACOUT 0.07167f
C88 a_730_3288# a_730_288# 0.5208f
C89 a_12014_923# IDACDISABLE 1.99901f
C90 a_10846_923# a_12014_923# 0.01232f
C91 a_10262_923# op_amp_ver_2_0.IOAM 0.01919f
C92 a_11732_5491# a_13474_727# 0.75459f
C93 a_10180_247# a_10554_727# 0.08378f
C94 a_4162_288# a_4162_3288# 0.55718f
C95 nD0 a_1786_3288# 0.06299f
C96 a_12014_923# a_12014_1063# 4.48416f
C97 a_10262_923# a_11732_5491# 0.27905f
C98 a_10846_727# IDACDISABLE 0.07646f
C99 a_10846_923# a_10846_727# 0.90398f
C100 op_amp_ver_2_0.IOAM a_7330_288# 0.0542f
C101 a_6802_3288# a_6802_288# 0.52308f
C102 a_8780_247# IDACDISABLE 1.91414f
C103 a_10846_923# a_11732_5295# 0.82498f
C104 a_10846_923# a_8780_247# 0.85453f
C105 a_8968_2247# op_amp_ver_2_0.IOAM 0.0338f
C106 a_5746_3288# op_amp_ver_2_0.IOAM 0.18675f
C107 a_1786_3288# a_1786_288# 0.55718f
C108 a_12014_1063# a_8780_247# 0.15803f
C109 IDACVTAP a_11732_5295# 0.03491f
C110 a_5218_3288# a_5218_288# 0.52308f
C111 a_4954_3288# a_5746_3288# 0.18525f
C112 a_2578_3288# a_2842_3288# 0.98837f
C113 a_11732_5295# a_10714_5055# 0.53342f
C114 a_12463_2551# a_8700_4135# 0.39934f
C115 a_4690_288# a_4162_3288# 0.0115f
C116 nD7 a_7280_4421# 0.03786f
C117 a_7594_388# op_amp_ver_2_0.IOAM 0.05911f
C118 a_2842_3288# a_3106_288# 0.19948f
C119 a_11420_5295# a_8700_4135# 0.02527f
C120 a_8780_247# a_10714_5055# 1.1682f
C121 a_3370_3288# a_3634_288# 0.08219f
C122 a_4954_3288# nD4 0.06299f
C123 a_12014_923# a_12014_727# 0.0559f
C124 a_10714_5055# a_11108_5819# 0.14162f
C125 a_11420_5819# a_8700_4135# 0.02526f
C126 IDACIREF a_8700_4135# 0.27054f
C127 a_12463_2551# ODACOUT 0.17281f
C128 a_466_3288# a_730_288# 0.07949f
C129 nD2 a_3106_288# 0.05869f
C130 IDACIREF ODACOUT 0.01438f
C131 nD1 a_2578_3288# 0.06299f
C132 a_8780_247# a_12014_727# 0.0128f
C133 a_12014_1063# a_15606_247# 0.19362f
C134 a_12014_923# a_11732_5491# 0.44908f
C135 a_994_3288# a_1258_3288# 0.98586f
C136 w_7156_4139# IDACDISABLE 0.29358f
C137 a_7280_4421# IDACDISABLE 0.07735f
C138 a_6010_3288# a_6274_288# 0.19948f
C139 a_10846_727# op_amp_ver_2_0.IOAM 0.13029f
C140 op_amp_ver_2_0.IOAM a_6802_288# 0.08312f
C141 a_11732_5295# op_amp_ver_2_0.IOAM 0.17628f
C142 a_730_288# a_994_288# 0.69758f
C143 a_4954_3288# a_5746_288# 0.03164f
C144 a_9424_2247# IDACDISABLE 0.13387f
C145 a_8780_247# op_amp_ver_2_0.IOAM 0.32634f
C146 a_5746_3288# a_6010_288# 0.08219f
C147 a_12463_2551# a_10180_247# 0.03854f
C148 a_11732_5295# a_11732_5491# 1.81337f
C149 a_4426_3288# a_4690_288# 0.19948f
C150 a_11732_5491# a_8780_247# 1.52267f
C151 IDACDISABLE a_8700_4135# 0.26201f
C152 a_1522_288# a_1786_3288# 0.0671f
C153 a_4954_3288# a_5218_288# 0.08219f
C154 a_2050_3288# a_2314_288# 0.19948f
C155 a_9272_2247# a_8780_247# 0.77964f
C156 a_2314_288# a_2578_288# 0.69758f
C157 a_4426_3288# a_4162_3288# 0.98837f
C158 a_12014_1063# a_8700_4135# 0.08309f
C159 a_2578_288# a_2842_288# 0.69758f
C160 a_11420_5819# a_10180_247# 0.08089f
C161 a_10180_247# IDACIREF 0.72421f
C162 a_7594_388# a_7330_288# 0.65107f
C163 a_3370_3288# a_3370_288# 0.55718f
C164 IDACDISABLE ODACOUT 0.17243f
C165 a_12014_923# a_13474_727# 0.01059f
C166 a_6274_288# nD6 0.05869f
C167 a_8700_4135# a_10714_5055# 1.63989f
C168 a_12014_923# a_10262_923# 0.04127f
C169 a_466_3288# a_466_288# 0.56426f
C170 a_12014_1063# ODACOUT 0.02556f
C171 nD3 a_3898_288# 0.05869f
C172 nD2 a_2842_3288# 0.06299f
C173 ODACOUT a_10714_5055# 0.12457f
C174 nD3 nD4 0.0239f
C175 a_8780_247# a_13474_727# 0.35528f
C176 a_10262_923# a_11732_5295# 0.1462f
C177 a_10262_923# a_8780_247# 0.66318f
C178 a_5746_288# a_6010_288# 0.69758f
C179 nD2 nD3 0.0239f
C180 op_amp_ver_2_0.IOAM a_6538_288# 0.55759f
C181 a_10180_247# IDACDISABLE 0.6805f
C182 a_9120_2247# IDACDISABLE 0.0154f
C183 a_10846_923# a_10180_247# 0.40481f
C184 a_5746_3288# a_5746_288# 0.55718f
C185 a_8780_247# a_7330_288# 0.03834f
C186 a_9424_2247# op_amp_ver_2_0.IOAM 0.02578f
C187 w_7156_4139# a_7384_3755# 0.04463f
C188 nD1 nD2 0.0239f
C189 a_7280_4421# a_7384_3755# 0.05948f
C190 a_9552_4067# a_8700_4135# 1.92026f
C191 a_1258_288# a_1522_288# 0.69758f
C192 a_1258_3288# a_1786_3288# 0.39239f
C193 a_4954_3288# a_4954_288# 0.55718f
C194 a_1786_3288# a_2314_288# 0.0115f
C195 a_1786_288# a_2050_288# 0.69758f
C196 a_8968_2247# a_8780_247# 0.90876f
C197 a_9272_2247# a_9424_2247# 1.16394f
C198 a_2578_3288# a_3370_3288# 0.18525f
C199 a_10180_247# a_10714_5055# 0.22878f
C200 a_11732_5491# a_8700_4135# 0.36617f
C201 a_3106_288# a_3370_3288# 0.08008f
C202 nD0 nD1 0.0239f
C203 a_7066_288# nD7 0.05869f
C204 a_3634_3288# a_3898_288# 0.19948f
C205 a_9552_4067# ODACOUT 0.05002f
C206 a_6010_3288# nD6 0.06299f
C207 op_amp_ver_2_0.IOAM ODACOUT 0.10308f
C208 a_11732_5491# ODACOUT 0.145f
C209 a_730_3288# a_994_3288# 0.85397f
C210 nD3 a_3634_3288# 0.06299f
C211 a_5482_288# nD5 0.05869f
C212 ODACOUT a_7384_3755# 0.16334f
C213 a_10180_247# a_12014_727# 0.02169f
C214 a_12014_923# a_8780_247# 0.0276f
C215 nD6 nD7 0.0239f
C216 a_9280_4067# a_9552_4067# 1.11545f
C217 a_994_3288# a_1786_3288# 0.18525f
C218 a_12306_727# IDACDISABLE 0.01002f
C219 a_7330_288# a_7280_4421# 0.03723f
C220 a_10262_923# a_8700_4135# 0.46873f
C221 a_6274_288# op_amp_ver_2_0.IOAM 0.08024f
C222 a_10846_923# a_12306_727# 0.13855f
C223 a_6802_3288# a_7066_288# 0.19948f
C224 nD5 nD6 0.0239f
C225 a_10846_923# a_12463_2551# 0.80877f
C226 a_10180_247# op_amp_ver_2_0.IOAM 0.51974f
C227 a_10846_727# a_8780_247# 0.39753f
C228 a_12306_727# a_12014_1063# 0.3829f
C229 a_5746_3288# a_6538_288# 0.03164f
C230 a_9120_2247# op_amp_ver_2_0.IOAM 0.02969f
C231 a_12463_2551# a_12014_1063# 0.03403f
C232 a_1258_3288# a_1258_288# 0.44221f
C233 a_10180_247# a_11732_5491# 0.40412f
C234 a_4690_288# a_4954_3288# 0.08008f
C235 a_1786_3288# a_2050_3288# 0.98837f
C236 IDACVTAP a_12463_2551# 0.1044f
C237 IDACIREF IDACDISABLE 0.0418f
C238 a_5218_3288# a_5482_288# 0.19948f
C239 a_10262_923# ODACOUT 0.15908f
C240 a_2314_288# a_2578_3288# 0.08008f
C241 a_1786_3288# a_2578_288# 0.03164f
C242 a_7594_388# a_7280_4421# 0.04027f
C243 a_9120_2247# a_9272_2247# 1.16394f
C244 a_2578_3288# a_2842_288# 0.08219f
C245 a_14228_5819# a_8700_4135# 0.02522f
C246 a_12463_2551# a_10714_5055# 0.55257f
C247 a_4954_3288# a_4162_3288# 0.18525f
C248 a_2842_3288# a_3370_3288# 0.32735f
C249 a_2842_288# a_3106_288# 0.69758f
C250 a_11420_5295# a_10714_5055# 0.04673f
C251 a_6802_3288# nD7 0.06299f
C252 a_3370_288# a_3634_288# 0.69758f
C253 a_3370_3288# a_3898_288# 0.0115f
C254 a_12014_923# a_15606_247# 0.09762f
C255 a_11420_5819# a_10714_5055# 0.03927f
C256 IDACIREF a_10714_5055# 0.03527f
C257 a_466_288# a_730_288# 0.69758f
C258 a_5218_3288# nD5 0.06299f
C259 a_4162_288# a_4426_288# 0.69758f
C260 nD2 a_3370_3288# 0.06299f
C261 a_4162_288# a_3898_288# 0.69758f
C262 nD0 a_1522_288# 0.05869f
C263 a_10262_923# a_10180_247# 0.05618f
C264 a_994_3288# a_1258_288# 0.16229f
C265 a_10846_923# IDACDISABLE 0.07302f
C266 a_6010_288# a_6274_288# 0.69758f
C267 a_6010_3288# op_amp_ver_2_0.IOAM 0.329f
C268 op_amp_ver_2_0.IOAM a_7066_288# 0.01173f
C269 a_6538_288# a_6802_288# 0.69758f
C270 a_12014_1063# IDACDISABLE 0.12604f
C271 a_12463_2551# op_amp_ver_2_0.IOAM 0.20363f
C272 a_994_3288# a_994_288# 0.48456f
C273 a_10846_923# a_12014_1063# 0.0269f
C274 a_12306_727# a_11732_5491# 1.45523f
C275 a_5746_3288# a_6274_288# 0.0115f
C276 a_12463_2551# a_11732_5491# 0.53483f
C277 IDACVTAP a_10846_923# 0.45489f
C278 a_4426_3288# a_4954_3288# 0.32735f
C279 a_4426_288# a_4690_288# 0.69758f
C280 a_1522_288# a_1786_288# 0.69758f
C281 a_4954_3288# a_5482_288# 0.0115f
C282 a_4954_288# a_5218_288# 0.69758f
C283 a_12014_923# ODACOUT 0.42979f
C284 a_2050_288# a_2314_288# 0.69758f
C285 a_2050_3288# a_2578_3288# 0.32735f
C286 a_9424_2247# a_8780_247# 1.41361f
C287 a_8968_2247# a_9120_2247# 1.16394f
C288 op_amp_ver_2_0.IOAM IDACIREF 0.07746f
C289 a_2578_3288# a_2578_288# 0.55718f
C290 a_11732_5295# a_8700_4135# 0.38209f
C291 a_4426_288# a_4162_3288# 0.08219f
C292 a_8780_247# a_8700_4135# 0.74808f
C293 a_12014_1063# a_10714_5055# 0.05868f
C294 a_2842_3288# a_2842_288# 0.52308f
C295 a_3370_3288# a_3634_3288# 0.98837f
C296 a_3898_288# a_4162_3288# 0.08008f
C297 a_4690_288# nD4 0.05869f
C298 op_amp_ver_2_0.IOAM nD6 0.06299f
C299 a_8700_4135# a_11108_5819# 0.02549f
C300 a_11732_5295# ODACOUT 0.25908f
C301 a_466_3288# a_730_3288# 0.86111f
C302 a_8780_247# ODACOUT 0.0659f
C303 nD3 a_4162_3288# 0.06299f
C304 nD7 0 1.03539f
C305 nD6 0 0.98365f
C306 nD5 0 0.98364f
C307 nD4 0 0.98364f
C308 nD3 0 0.98364f
C309 nD2 0 0.98364f
C310 nD1 0 0.98364f
C311 nD0 0 1.00197f
C312 a_12014_727# 0 0.02208f
C313 a_10554_727# 0 0.0301f
C314 a_13474_727# 0 3.59785f
C315 a_12306_727# 0 12.23428f
C316 a_10846_727# 0 4.86566f
C317 a_10846_923# 0 3.80485f
C318 a_9424_2247# 0 0.28202f
C319 a_9272_2247# 0 0.19076f
C320 a_9120_2247# 0 0.20021f
C321 a_8968_2247# 0 0.60364f
C322 a_6802_3288# 0 2.58406f
C323 op_amp_ver_2_0.IOAM 0 2.20838f
C324 a_6010_3288# 0 2.34789f
C325 a_5746_3288# 0 3.48522f
C326 a_5218_3288# 0 2.34788f
C327 a_4954_3288# 0 3.48519f
C328 a_4426_3288# 0 2.34788f
C329 a_4162_3288# 0 3.48519f
C330 a_3634_3288# 0 2.34788f
C331 a_3370_3288# 0 3.48519f
C332 a_2842_3288# 0 2.34788f
C333 a_2578_3288# 0 3.48519f
C334 a_2050_3288# 0 2.34788f
C335 a_1786_3288# 0 3.4727f
C336 a_1258_3288# 0 2.33321f
C337 a_994_3288# 0 3.42832f
C338 a_730_3288# 0 2.27489f
C339 a_466_3288# 0 3.1163f
C340 a_14228_5819# 0 0.32051f
C341 a_12463_2551# 0 2.53911f
C342 a_11732_5295# 0 3.76887f
C343 ODACOUT 0 0.74092p
C344 a_7280_4421# 0 2.08709f
C345 PDACVSS.t246 0 3.40264f
C346 PDACVSS.t257 0 3.40264f
C347 PDACVSS.t184 0 5.3797f
C348 PDACVSS.t189 0 3.28155f
C349 PDACVSS.t166 0 4.56665f
C350 PDACVSS.t206 0 1.84736f
C351 PDACVSS.t207 0 1.84736f
C352 PDACVSS.t9 0 0.74915f
C353 PDACVSS.t48 0 1.2678f
C354 PDACVSS.t49 0 1.2678f
C355 PDACVSS.t202 0 0.76851f
C356 PDACVSS.t197 0 1.21427f
C357 PDACVSS.t203 0 0.76851f
C358 PDACVSS.t196 0 1.21427f
C359 PDACVSS.t226 0 3.40809f
C360 PDACVSS.t204 0 0.86263f
C361 PDACVSS.t231 0 3.40264f
C362 PDACVSS.t234 0 3.40264f
C363 PDACVSS.t241 0 3.40264f
C364 PDACVSS.t251 0 3.40264f
C365 PDACVSS.t260 0 3.40821f
C366 PDACVDD.n0 0 0.02252f
C367 PDACVDD.n1 0 0.02252f
C368 PDACVDD.n2 0 0.02151f
C369 PDACVDD.n3 0 0.03321f
C370 PDACVDD.n4 0 0.03321f
C371 PDACVDD.n5 0 0.03321f
C372 PDACVDD.t0 0 64.0894f
C373 PDACVDD.n7 0 0.02151f
C374 PDACVDD.t50 0 0.08012f
C375 PDACVDD.n8 0 1.9923f
C376 PDACVDD.n9 0 0.3779f
C377 PDACVDD.n10 0 0.3779f
C378 PDACVDD.n11 0 0.3779f
C379 PDACVDD.n12 0 0.5185f
C380 PDACVDD.n13 0 0.33826f
C381 PDACVDD.n14 0 0.75071f
C382 PDACVDD.t128 0 0.04624f
C383 PDACVDD.t129 0 0.04624f
C384 PDACVDD.t130 0 0.04624f
C385 PDACVDD.t131 0 0.04624f
C386 PDACVDD.t35 0 0.08012f
C387 PDACVDD.t138 0 3.45473f
C388 PDACVDD.t139 0 0.04624f
C389 PDACVDD.t140 0 0.04624f
C390 PDACVDD.t141 0 0.04624f
C391 PDACVDD.t2 0 2.62766f
C392 PDACVDD.t91 0 0.02312f
C393 PDACVDD.t89 0 0.02312f
C394 PDACVDD.t88 0 0.02312f
C395 PDACVDD.t87 0 0.02312f
C396 PDACVDD.t86 0 0.02312f
C397 PDACVDD.t85 0 0.02312f
C398 PDACVDD.t84 0 0.02312f
C399 PDACVDD.t83 0 0.02312f
C400 PDACVDD.t82 0 0.02312f
C401 PDACVDD.t81 0 0.02734f
C402 PDACVDD.t80 0 0.02312f
C403 PDACVDD.t98 0 0.02446f
C404 PDACVDD.t67 0 0.02312f
C405 PDACVDD.t71 0 0.02312f
C406 PDACVDD.t66 0 0.02312f
C407 PDACVDD.t79 0 0.02786f
C408 PDACVDD.t70 0 0.02584f
C409 PDACVDD.t104 0 0.02514f
C410 PDACVDD.t102 0 0.02312f
C411 PDACVDD.t68 0 0.02718f
C412 PDACVDD.t95 0 0.02532f
C413 PDACVDD.t97 0 0.01935f
C414 PDACVDD.t3 0 3.04196f
C415 PDACVDD.t78 0 0.02312f
C416 PDACVDD.t69 0 0.02312f
C417 PDACVDD.t5 0 0.01574f
C418 PDACVDD.t94 0 0.01927f
C419 PDACVDD.t93 0 0.01927f
C420 PDACVDD.t96 0 0.01927f
C421 PDACVDD.t63 0 0.02312f
C422 PDACVDD.t64 0 0.02312f
C423 PDACVDD.t72 0 0.02312f
C424 PDACVDD.t65 0 0.02312f
C425 PDACVDD.t61 0 0.02324f
C426 PDACVDD.t62 0 0.02387f
C427 PDACVDD.t73 0 0.02391f
C428 PDACVDD.t74 0 0.02312f
C429 PDACVDD.t75 0 0.34363f
C430 PDACVDD.t76 0 0.02312f
C431 PDACVDD.t8 0 0.084f
C432 PDACVDD.t15 0 0.084f
C433 PDACVDD.t77 0 0.02687f
C434 PDACVDD.t14 0 0.084f
C435 PDACVDD.t100 0 0.02415f
C436 PDACVDD.t20 0 0.084f
C437 PDACVDD.t27 0 0.084f
C438 PDACVDD.t92 0 0.02584f
C439 PDACVDD.t90 0 0.02786f
C440 PDACVDD.t26 0 0.084f
C441 PDACVDD.t33 0 0.084f
C442 PDACVDD.t32 0 0.084f
C443 PDACVDD.t11 0 0.08012f
C444 PDACVDD.t110 0 0.04624f
C445 PDACVDD.t108 0 0.04624f
C446 PDACVDD.t107 0 3.45898f
C447 PDACVDD.t1 0 0.05956f
C448 PDACVDD.t9 0 0.08012f
C449 PDACVDD.t21 0 0.084f
C450 PDACVDD.t106 0 0.02312f
C451 PDACVDD.t105 0 0.02514f
C452 PDACVDD.t39 0 0.084f
C453 PDACVDD.t38 0 0.084f
C454 PDACVDD.t48 0 0.13579f
C455 PDACVDD.t45 0 0.04624f
C456 PDACVDD.t47 0 0.13579f
C457 PDACVDD.t44 0 0.04624f
C458 PDACVDD.t51 0 0.08399f
C459 PDACVDD.t42 0 0.08399f
C460 PDACVDD.t36 0 0.08399f
C461 PDACVDD.t24 0 0.08399f
C462 PDACVDD.t23 0 0.08012f
C463 PDACVDD.t121 0 3.45473f
C464 PDACVDD.t120 0 0.04624f
C465 PDACVDD.t119 0 0.04624f
C466 PDACVDD.t118 0 0.04624f
C467 PDACVDD.t117 0 0.0475f
C468 PDACVDD.t112 0 3.45598f
C469 PDACVDD.t41 0 0.08012f
C470 PDACVDD.t136 0 0.04624f
C471 PDACVDD.t135 0 0.04624f
C472 PDACVDD.t134 0 0.04624f
C473 PDACVDD.t133 0 0.04624f
C474 PDACVDD.t137 0 0.0475f
C475 PDACVDD.t132 0 3.45598f
C476 PDACVDD.t29 0 0.08012f
C477 PDACVDD.t126 0 0.04624f
C478 PDACVDD.t125 0 3.45473f
C479 PDACVDD.t124 0 0.04624f
C480 PDACVDD.t123 0 0.04624f
C481 PDACVDD.t127 0 3.45599f
C482 PDACVDD.t122 0 0.04749f
C483 PDACVDD.t113 0 0.04624f
C484 PDACVDD.t114 0 0.04624f
C485 PDACVDD.t115 0 0.04624f
C486 PDACVDD.t116 0 0.04624f
C487 PDACVDD.t17 0 0.08012f
C488 PDACVDD.t18 0 0.08399f
C489 PDACVDD.t12 0 0.08399f
C490 PDACVDD.t109 0 0.04624f
C491 PDACVDD.t111 0 0.04624f
C492 PDACVDD.t30 0 0.08399f
C493 PDACVDD.t59 0 0.08399f
C494 PDACVDD.t60 0 0.08012f
C495 PDACVDD.t146 0 0.04624f
C496 PDACVDD.t145 0 0.04624f
C497 PDACVDD.t144 0 0.04624f
C498 PDACVDD.t143 0 0.04624f
C499 PDACVDD.t142 0 3.45898f
C500 PDACVDD.t57 0 0.12137f
C501 PDACVDD.t54 0 0.04624f
C502 PDACVDD.t56 0 0.13579f
C503 PDACVDD.t53 0 0.04624f
C504 ODACOUT.t46 0 7.70664f
C505 ODACOUT.t47 0 11.10927f
C506 ODACOUT.t36 0 7.70664f
C507 ODACOUT.t4 0 15.87434f
C508 ODACOUT.t10 0 19.27858f
C509 ODACOUT.t35 0 0.30493p
C510 ODACOUT.t5 0 12.06734f
C511 ODACOUT.t32 0 3.85332f
C512 ODACOUT.t29 0 0.59219f
C513 ODACOUT.t16 0 0.59219f
C514 ODACOUT.t18 0 2.44938f
C515 ODACOUT.t23 0 16.22523f
C516 ODACOUT.t9 0 0.59219f
C517 ODACOUT.t17 0 0.59219f
C518 ODACOUT.t14 0 0.59219f
C519 ODACOUT.t30 0 0.59219f
C520 ODACOUT.t40 0 0.2961f
C521 ODACOUT.t31 0 0.2961f
C522 ODACOUT.t38 0 3.69873f
C523 ODACOUT.t58 0 0.2961f
C524 ODACOUT.t45 0 3.69873f
C525 ODACOUT.t57 0 0.2961f
C526 ODACOUT.t52 0 3.69873f
C527 ODACOUT.t43 0 0.2961f
C528 ODACOUT.t1 0 3.80276f
C529 ODACOUT.t21 0 0.59219f
C530 ODACOUT.t27 0 4.00068f
C531 ODACOUT.t0 0 0.60832f
C532 ODACOUT.t13 0 0.59219f
C533 ODACOUT.t19 0 0.59219f
C534 ODACOUT.t6 0 0.59219f
C535 ODACOUT.t28 0 0.59219f
C536 ODACOUT.t8 0 0.59219f
C537 ODACOUT.t2 0 0.59219f
C538 ODACOUT.t24 0 0.59219f
C539 ODACOUT.t25 0 0.59219f
C540 ODACOUT.t11 0 0.59219f
C541 ODACOUT.t3 0 0.59219f
C542 ODACOUT.t26 0 0.59219f
C543 ODACOUT.t12 0 0.59219f
C544 ODACOUT.t22 0 0.59219f
C545 ODACOUT.t20 0 0.59219f
C546 ODACOUT.t7 0 0.59219f
C547 ODACOUT.t15 0 4.00068f
C548 ODACOUT.t42 0 3.70419f
C549 ODACOUT.t59 0 0.2961f
C550 ODACOUT.t51 0 0.2961f
C551 ODACOUT.t41 0 0.2961f
C552 ODACOUT.t54 0 0.2961f
C553 ODACOUT.t53 0 0.2961f
C554 ODACOUT.t44 0 0.2961f
C555 ODACOUT.t56 0 0.2961f
C556 ODACOUT.t34 0 0.2961f
C557 ODACOUT.t50 0 3.69873f
C558 ODACOUT.t49 0 0.2961f
C559 ODACOUT.t39 0 3.7043f
C560 ODACOUT.t55 0 0.2961f
C561 ODACOUT.t33 0 3.69873f
C562 ODACOUT.t37 0 0.2961f
C563 ODACOUT.t48 0 0.2961f
C564 a_12980_5491.n0 0 4.4731f
C565 a_12980_5491.n1 0 4.4731f
C566 a_12980_5491.n2 0 0.45666p
C567 a_12980_5491.n3 0 7.42673f
C568 a_12980_5491.n4 0 5.71904f
C569 a_12980_5491.t11 0 0.3962f
C570 a_12980_5491.t2 0 2.89048f
C571 a_12980_5491.t12 0 0.68097f
C572 a_12980_5491.t8 0 0.39857f
C573 a_12980_5491.t7 0 0.3962f
C574 a_12980_5491.t10 0 0.3962f
C575 a_12980_5491.t5 0 0.39852f
C576 a_12980_5491.t9 0 0.39857f
C577 a_12980_5491.t6 0 0.3962f
C578 a_12980_5491.t0 0 0.81091f
C579 a_12980_5491.t1 0 0.80049f
C580 a_12980_5491.t4 0 2.52105f
C581 a_12980_5491.t15 0 0.39852f
C582 a_12980_5491.t14 0 0.39857f
C583 a_12980_5491.t13 0 0.50671f
C584 a_12980_5491.t16 0 0.50671f
C585 a_12980_5491.n5 0 8.35539f
C586 a_12980_5491.t3 0 0.81091f
C587 a_13474_923.n0 0 0.5838f
C588 a_13474_923.n1 0 0.65475f
C589 a_13474_923.n2 0 0.73881f
C590 a_13474_923.n3 0 0.5838f
C591 a_13474_923.n4 0 0.65475f
C592 a_13474_923.n5 0 0.22645p
C593 a_13474_923.t3 0 2.91296f
C594 a_13474_923.t2 0 1.05986f
C595 a_13474_923.t1 0 1.05988f
C596 a_13474_923.t12 0 0.20818f
C597 a_13474_923.t11 0 0.20033f
C598 a_13474_923.t7 0 0.20033f
C599 a_13474_923.n6 0 1.38326f
C600 a_13474_923.t10 0 0.20033f
C601 a_13474_923.t6 0 0.20033f
C602 a_13474_923.n7 0 0.88174f
C603 a_13474_923.t9 0 0.20033f
C604 a_13474_923.t8 0 0.20033f
C605 a_13474_923.t4 0 0.20033f
C606 a_13474_923.n8 0 0.8294f
C607 a_13474_923.t5 0 0.20033f
C608 a_13474_923.n9 0 0.88174f
C609 a_13474_923.n10 0 1.47685f
C610 a_13474_923.n11 0 1.0446f
C611 a_13474_923.n12 0 0.41772f
C612 a_13474_923.n13 0 1.05252f
C613 a_13474_923.n14 0 0.41772f
C614 a_13474_923.t16 0 0.4012f
C615 a_13474_923.t15 0 0.40066f
C616 a_13474_923.n15 0 0.73881f
C617 a_13474_923.n16 0 0.41772f
C618 a_13474_923.n17 0 0.41772f
C619 a_13474_923.t13 0 0.40066f
C620 a_13474_923.t14 0 0.4012f
C621 a_13474_923.n18 0 0.22775p
C622 a_13474_923.n19 0 5.282f
C623 a_13474_923.n20 0 1.63845f
C624 a_13474_923.t0 0 0.82313f
.ends
