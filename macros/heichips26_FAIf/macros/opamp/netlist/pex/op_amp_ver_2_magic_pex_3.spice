* PEX produced on Thu Oct  8 02:15:53 CEST 2026 using scripts/sak-pex.sh with m=3 and s=1 (extresist threshold=10000 mOhm, minres=1000 mOhm, mindelay=1 ps)
* NGSPICE file created from op_amp_ver_2_pex.ext - technology: ihp-sg13cmos5l

.subckt op_amp_ver_2_pex OOA IOADISABLE IOAIREF POAVSS POAVDD IOAP IOAM
X0 a_848_4062# a_268_4130# a_1120_4062# POAVDD sg13_hv_pmos ad=0.34p pd=2.68u as=0.34p ps=2.68u w=1u l=10u
X1 POAVDD a_4548_5486.t18 OOA POAVDD sg13_hv_pmos ad=0.816p pd=5.48u as=0.816p ps=5.48u w=2.4u l=0.4u
X2 POAVSS.t1 a_348_242# POAVSS.t75 POAVSS.t74 sg13_hv_nmos ad=0.136p pd=1.48u as=0 ps=0 w=0.4u l=10u
X3 POAVSS.t11 a_5042_918.t18 OOA POAVSS.t10 sg13_hv_nmos ad=0.408p pd=3.08u as=0.408p ps=3.08u w=1.2u l=0.6u
X4 POAVDD a_268_4130# POAVDD POAVDD sg13_hv_pmos ad=0.408p pd=3.08u as=0.26442n ps=0.66388m w=1.2u l=0.6u
X5 a_2414_722# a_1748_242# POAVSS.t46 POAVSS.t40 sg13_hv_nmos ad=0.114p pd=0.98u as=0.204p ps=1.88u w=0.6u l=2.4u
X6 a_3300_5486# a_348_242# a_3874_722# POAVSS.t52 sg13_hv_nmos ad=0.204p pd=1.88u as=0.114p ps=0.98u w=0.6u l=0.6u
X7 POAVSS.t23 a_5042_918.t20 OOA POAVSS.t10 sg13_hv_nmos ad=0.408p pd=3.08u as=0.408p ps=3.08u w=1.2u l=0.6u
X8 OOA a_5042_918.t21 POAVSS.t35 POAVSS.t14 sg13_hv_nmos ad=0.408p pd=3.08u as=0.408p ps=3.08u w=1.2u l=0.6u
X9 a_3874_722# a_348_242# a_3300_5486# POAVSS.t50 sg13_hv_nmos ad=0.114p pd=0.98u as=0.204p ps=1.88u w=0.6u l=0.6u
X10 a_4031_2546# a_268_4130# a_4548_5486.t3 POAVDD sg13_hv_pmos ad=0.228p pd=1.58u as=0.408p ps=3.08u w=1.2u l=0.6u
X11 POAVSS.t120 POAVSS.t1 POAVSS.t119 POAVSS.t96 sg13_hv_nmos ad=0.408p pd=3.08u as=0 ps=0 w=1.2u l=0.45u
X12 POAVSS.t5 a_348_242# POAVSS.t5 POAVSS.t4 sg13_hv_nmos ad=0.114p pd=0.98u as=0 ps=0 w=0.6u l=0.6u
X13 POAVDD a_268_4130# POAVDD POAVDD sg13_hv_pmos ad=0.228p pd=1.58u as=0 ps=0 w=1.2u l=0.6u
X14 a_3582_1058# a_3582_1058# a_7174_242# POAVSS.t78 sg13_hv_nmos ad=0.408p pd=3.08u as=0.408p ps=3.08u w=1.2u l=0.6u
X15 POAVSS.t1 a_3300_5486# a_3874_722# POAVSS.t50 sg13_hv_nmos ad=0.204p pd=1.88u as=0.114p ps=0.98u w=0.6u l=2.4u
X16 POAVDD a_2282_5050# a_4031_2546# POAVDD sg13_hv_pmos ad=0.408p pd=3.08u as=0.228p ps=1.58u w=1.2u l=1.2u
X17 a_4031_2546# a_268_4130# a_4548_5486.t0 POAVDD sg13_hv_pmos ad=0.228p pd=1.58u as=0.408p ps=3.08u w=1.2u l=0.6u
X18 a_3300_5290# a_2282_5050# POAVDD POAVDD sg13_hv_pmos ad=0.228p pd=1.58u as=0.408p ps=3.08u w=1.2u l=1.2u
X19 POAVDD a_4548_5486.t18 OOA POAVDD sg13_hv_pmos ad=0.816p pd=5.48u as=0.816p ps=5.48u w=2.4u l=0.4u
X20 POAVSS.t5 POAVSS.t5 POAVSS.t5 POAVSS.t4 sg13_hv_nmos ad=0.204p pd=1.88u as=0 ps=0 w=0.6u l=2.4u
X21 a_3874_722# a_3300_5486# POAVSS.t60 POAVSS.t52 sg13_hv_nmos ad=0.114p pd=0.98u as=0.204p ps=1.88u w=0.6u l=2.4u
X22 POAVDD a_2282_5050# POAVDD POAVDD sg13_hv_pmos ad=0.408p pd=3.08u as=0 ps=0 w=1.2u l=1.2u
X23 a_2988_5814# a_268_4130# a_1748_242# POAVDD sg13_hv_pmos ad=0.228p pd=1.58u as=0.408p ps=3.08u w=1.2u l=0.6u
X24 POAVDD a_4548_5486.t18 OOA POAVDD sg13_hv_pmos ad=0.816p pd=5.48u as=0.816p ps=5.48u w=2.4u l=0.4u
X25 POAVSS.t5 POAVSS.t5 POAVSS.t5 POAVSS.t130 sg13_hv_nmos ad=0.408p pd=3.08u as=0 ps=0 w=1.2u l=0.6u
X26 POAVDD POAVDD POAVDD POAVDD sg13_hv_pmos ad=0.816p pd=5.48u as=0 ps=0 w=2.4u l=0.4u
X27 POAVDD a_2282_5050# a_4031_2546# POAVDD sg13_hv_pmos ad=0.408p pd=3.08u as=0.228p ps=1.58u w=1.2u l=1.2u
X28 POAVDD a_7427_6047# a_7427_6047# POAVDD sg13_hv_pmos ad=0.816p pd=5.48u as=0.816p ps=5.48u w=2.4u l=0.4u
X29 POAVDD a_4548_5486.t18 OOA POAVDD sg13_hv_pmos ad=0.816p pd=5.48u as=0.816p ps=5.48u w=2.4u l=0.4u
X30 POAVDD a_2282_5050# a_2988_5814# POAVDD sg13_hv_pmos ad=0.408p pd=3.08u as=0.228p ps=1.58u w=1.2u l=1.2u
X31 a_4548_5486.t6 a_268_4130# a_4031_2546# POAVDD sg13_hv_pmos ad=0.408p pd=3.08u as=0.228p ps=1.58u w=1.2u l=0.6u
X32 POAVDD POAVDD POAVDD POAVDD sg13_hv_pmos ad=0.816p pd=5.48u as=0 ps=0 w=2.4u l=0.4u
X33 a_1748_242# a_348_242# a_2122_722# POAVSS.t38 sg13_hv_nmos ad=0.204p pd=1.88u as=0.114p ps=0.98u w=0.6u l=0.6u
X34 POAVDD a_4548_5486.t22 OOA POAVDD sg13_hv_pmos ad=0.816p pd=5.48u as=0.816p ps=5.48u w=2.4u l=0.4u
X35 a_992_2242# a_348_242# a_840_2242# POAVSS.t72 sg13_hv_nmos ad=0.136p pd=1.48u as=0.136p ps=1.48u w=0.4u l=10u
X36 POAVSS.t1 IOAIREF POAVSS.t1 POAVSS.t94 sg13_hv_nmos ad=0.204p pd=1.88u as=0 ps=0 w=0.6u l=2.4u
X37 POAVSS.t106 POAVSS.t106 POAVSS.t106 POAVSS.t107 sg13_hv_nmos ad=0.408p pd=3.08u as=0 ps=0 w=1.2u l=0.45u
X38 POAVSS.t19 a_5042_918.t24 OOA POAVSS.t12 sg13_hv_nmos ad=0.408p pd=3.08u as=0.408p ps=3.08u w=1.2u l=0.6u
X39 a_576_4062# a_268_4130# a_848_4062# POAVDD sg13_hv_pmos ad=0.34p pd=2.68u as=0.34p ps=2.68u w=1u l=10u
X40 a_3300_5486# a_268_4130# a_3300_5290# POAVDD sg13_hv_pmos ad=0.408p pd=3.08u as=0.228p ps=1.58u w=1.2u l=0.6u
X41 OOA a_5042_918.t17 POAVSS.t178 POAVSS.t8 sg13_hv_nmos ad=0.408p pd=3.08u as=0.408p ps=3.08u w=1.2u l=0.6u
X42 a_3582_918# a_348_242# a_3582_722# POAVSS.t0 sg13_hv_nmos ad=0.204p pd=1.88u as=0.114p ps=0.98u w=0.6u l=0.6u
X43 POAVDD a_268_4130# POAVDD POAVDD sg13_hv_pmos ad=0.408p pd=3.08u as=0 ps=0 w=1.2u l=0.6u
X44 POAVSS.t5 POAVSS.t5 POAVSS.t5 POAVSS.t78 sg13_hv_nmos ad=0.408p pd=3.08u as=0 ps=0 w=1.2u l=0.6u
X45 a_2122_722# a_1748_242# POAVSS.t44 POAVSS.t38 sg13_hv_nmos ad=0.114p pd=0.98u as=0.204p ps=1.88u w=0.6u l=2.4u
X46 POAVDD a_268_4130# POAVDD POAVDD sg13_hv_pmos ad=0.228p pd=1.58u as=0 ps=0 w=1.2u l=0.6u
X47 a_5042_918.t9 a_348_242# a_5042_722# POAVSS.t55 sg13_hv_nmos ad=0.204p pd=1.88u as=0.114p ps=0.98u w=0.6u l=0.6u
X48 POAVDD a_4548_5486.t22 OOA POAVDD sg13_hv_pmos ad=0.816p pd=5.48u as=0.816p ps=5.48u w=2.4u l=0.4u
X49 a_3582_722# a_1748_242# POAVSS.t47 POAVSS.t0 sg13_hv_nmos ad=0.114p pd=0.98u as=0.204p ps=1.88u w=0.6u l=2.4u
X50 POAVDD a_4548_5486.t22 OOA POAVDD sg13_hv_pmos ad=0.816p pd=5.48u as=0.816p ps=5.48u w=2.4u l=0.4u
X51 POAVDD a_2282_5050# POAVDD POAVDD sg13_hv_pmos ad=0.408p pd=3.08u as=0 ps=0 w=1.2u l=1.2u
X52 OOA a_5042_918.t19 POAVSS.t81 POAVSS.t10 sg13_hv_nmos ad=0.408p pd=3.08u as=0.408p ps=3.08u w=1.2u l=0.6u
X53 OOA a_5042_918.t21 POAVSS.t34 POAVSS.t12 sg13_hv_nmos ad=0.408p pd=3.08u as=0.408p ps=3.08u w=1.2u l=0.6u
X54 POAVDD POAVDD POAVDD POAVDD sg13_hv_pmos ad=0.816p pd=5.48u as=0 ps=0 w=2.4u l=0.4u
X55 POAVDD a_4548_5486.t22 OOA POAVDD sg13_hv_pmos ad=0.816p pd=5.48u as=0.816p ps=5.48u w=2.4u l=0.4u
X56 POAVSS.t13 a_5042_918.t18 OOA POAVSS.t12 sg13_hv_nmos ad=0.408p pd=3.08u as=0.408p ps=3.08u w=1.2u l=0.6u
X57 POAVSS.t5 POAVSS.t5 POAVSS.t5 POAVSS.t130 sg13_hv_nmos ad=0.408p pd=3.08u as=0 ps=0 w=1.2u l=0.6u
X58 a_5042_722# a_3300_5486# POAVSS.t60 POAVSS.t55 sg13_hv_nmos ad=0.114p pd=0.98u as=0.204p ps=1.88u w=0.6u l=2.4u
X59 a_5042_722# a_348_242# a_5042_918.t5 POAVSS.t55 sg13_hv_nmos ad=0.114p pd=0.98u as=0.204p ps=1.88u w=0.6u l=0.6u
X60 a_2414_918# IOAM a_3300_5290# POAVSS.t103 sg13_hv_nmos ad=0.816p pd=5.48u as=0.816p ps=5.48u w=2.4u l=0.45u
X61 POAVDD a_2282_5050# POAVDD POAVDD sg13_hv_pmos ad=0.228p pd=1.58u as=0 ps=0 w=1.2u l=1.2u
X62 a_348_242# a_348_242# a_992_2242# POAVSS.t73 sg13_hv_nmos ad=0.136p pd=1.48u as=0.136p ps=1.48u w=0.4u l=10u
X63 POAVSS.t1 a_3300_5486# a_5042_722# POAVSS.t55 sg13_hv_nmos ad=0.204p pd=1.88u as=0.114p ps=0.98u w=0.6u l=2.4u
X64 a_5042_918.t14 a_3582_1058# a_4548_5486.t15 POAVSS.t78 sg13_hv_nmos ad=0.408p pd=3.08u as=0.408p ps=3.08u w=1.2u l=0.6u
X65 POAVDD POAVDD POAVDD POAVDD sg13_hv_pmos ad=0.816p pd=5.48u as=0 ps=0 w=2.4u l=0.4u
X66 a_4548_5486.t9 a_3582_918# a_5042_918.t1 POAVDD sg13_hv_pmos ad=0.816p pd=5.48u as=0.816p ps=5.48u w=2.4u l=0.4u
X67 POAVSS.t152 POAVSS.t152 POAVSS.t153 POAVSS.t137 sg13_hv_nmos ad=0.408p pd=3.08u as=0 ps=0 w=1.2u l=0.6u
X68 POAVDD a_1830_918# a_3582_918# POAVDD sg13_hv_pmos ad=0.228p pd=1.58u as=0.408p ps=3.08u w=1.2u l=0.6u
X69 POAVDD a_4548_5486.t18 OOA POAVDD sg13_hv_pmos ad=0.816p pd=5.48u as=0.816p ps=5.48u w=2.4u l=0.4u
X70 a_2414_722# a_348_242# a_2414_918# POAVSS.t40 sg13_hv_nmos ad=0.114p pd=0.98u as=0.204p ps=1.88u w=0.6u l=0.6u
X71 POAVDD a_4548_5486.t24 OOA POAVDD sg13_hv_pmos ad=0.816p pd=5.48u as=0.816p ps=5.48u w=2.4u l=0.4u
X72 OOA a_5042_918.t23 POAVSS.t86 POAVSS.t10 sg13_hv_nmos ad=0.408p pd=3.08u as=0.408p ps=3.08u w=1.2u l=0.6u
X73 a_5042_722# a_348_242# a_5042_918.t6 POAVSS.t56 sg13_hv_nmos ad=0.114p pd=0.98u as=0.204p ps=1.88u w=0.6u l=0.6u
X74 POAVSS.t102 POAVSS.t99 POAVSS.t101 POAVSS.t100 sg13_hv_nmos ad=0.816p pd=5.48u as=0 ps=0 w=2.4u l=0.45u
X75 a_4548_5486.t16 a_1830_918# POAVDD POAVDD sg13_hv_pmos ad=0.408p pd=3.08u as=0.228p ps=1.58u w=1.2u l=0.6u
X76 POAVSS.t1 a_1748_242# a_2414_722# POAVSS.t40 sg13_hv_nmos ad=0.204p pd=1.88u as=0.114p ps=0.98u w=0.6u l=2.4u
X77 POAVSS.t1 a_3300_5486# a_5042_722# POAVSS.t56 sg13_hv_nmos ad=0.204p pd=1.88u as=0.114p ps=0.98u w=0.6u l=2.4u
X78 a_4031_2546# a_2282_5050# POAVDD POAVDD sg13_hv_pmos ad=0.228p pd=1.58u as=0.408p ps=3.08u w=1.2u l=1.2u
X79 POAVSS.t152 POAVSS.t152 POAVSS.t161 POAVSS.t137 sg13_hv_nmos ad=0.408p pd=3.08u as=0 ps=0 w=1.2u l=0.6u
X80 a_4548_5486.t5 a_268_4130# a_4031_2546# POAVDD sg13_hv_pmos ad=0.408p pd=3.08u as=0.228p ps=1.58u w=1.2u l=0.6u
X81 a_5042_918.t12 a_348_242# a_5042_722# POAVSS.t58 sg13_hv_nmos ad=0.204p pd=1.88u as=0.114p ps=0.98u w=0.6u l=0.6u
X82 a_3300_5486# a_348_242# a_3874_722# POAVSS.t51 sg13_hv_nmos ad=0.204p pd=1.88u as=0.114p ps=0.98u w=0.6u l=0.6u
X83 POAVSS.t1 POAVSS.t1 POAVSS.t1 POAVSS.t96 sg13_hv_nmos ad=0.408p pd=3.08u as=0 ps=0 w=1.2u l=0.45u
X84 POAVSS.t135 POAVSS.t5 POAVSS.t5 POAVSS.t78 sg13_hv_nmos ad=0.408p pd=3.08u as=0 ps=0 w=1.2u l=0.6u
X85 a_3300_5290# a_2282_5050# POAVDD POAVDD sg13_hv_pmos ad=0.228p pd=1.58u as=0.408p ps=3.08u w=1.2u l=1.2u
X86 POAVDD a_4548_5486.t24 OOA POAVDD sg13_hv_pmos ad=0.816p pd=5.48u as=0.816p ps=5.48u w=2.4u l=0.4u
X87 a_5042_722# a_348_242# a_5042_918.t7 POAVSS.t57 sg13_hv_nmos ad=0.114p pd=0.98u as=0.204p ps=1.88u w=0.6u l=0.6u
X88 a_3300_5486# a_268_4130# a_3300_5290# POAVDD sg13_hv_pmos ad=0.408p pd=3.08u as=0.228p ps=1.58u w=1.2u l=0.6u
X89 POAVDD a_4548_5486.t24 OOA POAVDD sg13_hv_pmos ad=0.816p pd=5.48u as=0.816p ps=5.48u w=2.4u l=0.4u
X90 a_688_2242# a_348_242# a_536_2242# POAVSS.t70 sg13_hv_nmos ad=0.136p pd=1.48u as=0.136p ps=1.48u w=0.4u l=10u
X91 a_840_2242# a_348_242# a_688_2242# POAVSS.t71 sg13_hv_nmos ad=0.136p pd=1.48u as=0.136p ps=1.48u w=0.4u l=10u
X92 POAVDD a_2282_5050# POAVDD POAVDD sg13_hv_pmos ad=0.228p pd=1.58u as=0 ps=0 w=1.2u l=1.2u
X93 a_3300_5290# a_268_4130# a_3300_5486# POAVDD sg13_hv_pmos ad=0.228p pd=1.58u as=0.408p ps=3.08u w=1.2u l=0.6u
X94 a_7427_6047# a_3582_918# a_3582_918# POAVDD sg13_hv_pmos ad=0.816p pd=5.48u as=0.816p ps=5.48u w=2.4u l=0.4u
X95 POAVSS.t1 a_3300_5486# a_5042_722# POAVSS.t57 sg13_hv_nmos ad=0.204p pd=1.88u as=0.114p ps=0.98u w=0.6u l=2.4u
X96 POAVSS.t15 a_5042_918.t18 OOA POAVSS.t14 sg13_hv_nmos ad=0.408p pd=3.08u as=0.408p ps=3.08u w=1.2u l=0.6u
X97 a_5042_722# a_3300_5486# POAVSS.t60 POAVSS.t58 sg13_hv_nmos ad=0.114p pd=0.98u as=0.204p ps=1.88u w=0.6u l=2.4u
X98 a_3874_722# a_3300_5486# POAVSS.t54 POAVSS.t51 sg13_hv_nmos ad=0.114p pd=0.98u as=0.204p ps=1.88u w=0.6u l=2.4u
X99 POAVDD POAVDD POAVDD POAVDD sg13_hv_pmos ad=0.816p pd=5.48u as=0 ps=0 w=2.4u l=0.4u
X100 POAVDD a_4548_5486.t24 OOA POAVDD sg13_hv_pmos ad=0.816p pd=5.48u as=0.816p ps=5.48u w=2.4u l=0.4u
X101 POAVDD a_4548_5486.t22 OOA POAVDD sg13_hv_pmos ad=0.816p pd=5.48u as=0.816p ps=5.48u w=2.4u l=0.4u
X102 POAVDD a_2282_5050# a_3300_5290# POAVDD sg13_hv_pmos ad=0.408p pd=3.08u as=0.228p ps=1.58u w=1.2u l=1.2u
X103 POAVDD POAVDD POAVDD POAVDD sg13_hv_pmos ad=0.816p pd=5.48u as=0 ps=0 w=2.4u l=0.4u
X104 POAVDD IOADISABLE a_1830_918# POAVDD sg13_hv_pmos ad=0.228p pd=1.58u as=0.408p ps=3.08u w=1.2u l=0.6u
X105 OOA a_5042_918.t19 POAVSS.t82 POAVSS.t12 sg13_hv_nmos ad=0.408p pd=3.08u as=0.408p ps=3.08u w=1.2u l=0.6u
X106 POAVSS.t132 POAVSS.t5 POAVSS.t5 POAVSS.t130 sg13_hv_nmos ad=0.408p pd=3.08u as=0 ps=0 w=1.2u l=0.6u
X107 a_5042_918.t16 a_3582_1058# a_4548_5486.t13 POAVSS.t78 sg13_hv_nmos ad=0.408p pd=3.08u as=0.408p ps=3.08u w=1.2u l=0.6u
X108 POAVSS.t27 a_5042_918.t22 OOA POAVSS.t8 sg13_hv_nmos ad=0.408p pd=3.08u as=0.408p ps=3.08u w=1.2u l=0.6u
X109 a_5042_722# a_348_242# a_5042_918.t8 POAVSS.t58 sg13_hv_nmos ad=0.114p pd=0.98u as=0.204p ps=1.88u w=0.6u l=0.6u
X110 POAVSS.t90 IOAIREF POAVSS.t1 POAVSS.t38 sg13_hv_nmos ad=0.204p pd=1.88u as=0 ps=0 w=0.6u l=2.4u
X111 a_268_4130# a_1830_918# POAVDD POAVDD sg13_hv_pmos ad=0.408p pd=3.08u as=0.228p ps=1.58u w=1.2u l=0.6u
X112 a_3300_5486# a_268_4130# a_3300_5290# POAVDD sg13_hv_pmos ad=0.408p pd=3.08u as=0.228p ps=1.58u w=1.2u l=0.6u
X113 OOA a_4548_5486.t21 POAVDD POAVDD sg13_hv_pmos ad=0.816p pd=5.48u as=0.816p ps=5.48u w=2.4u l=0.4u
X114 POAVSS.t1 a_3300_5486# a_5042_722# POAVSS.t58 sg13_hv_nmos ad=0.204p pd=1.88u as=0.114p ps=0.98u w=0.6u l=2.4u
X115 a_3300_5290# IOAM a_2414_918# POAVSS.t100 sg13_hv_nmos ad=0.816p pd=5.48u as=0.816p ps=5.48u w=2.4u l=0.45u
X116 a_2414_918# a_348_242# a_2414_722# POAVSS.t41 sg13_hv_nmos ad=0.204p pd=1.88u as=0.114p ps=0.98u w=0.6u l=0.6u
X117 POAVSS.t172 POAVSS.t5 POAVSS.t5 POAVSS.t130 sg13_hv_nmos ad=0.408p pd=3.08u as=0 ps=0 w=1.2u l=0.6u
X118 a_3874_722# a_348_242# a_3300_5486# POAVSS.t51 sg13_hv_nmos ad=0.114p pd=0.98u as=0.204p ps=1.88u w=0.6u l=0.6u
X119 POAVDD POAVDD POAVDD POAVDD sg13_hv_pmos ad=0.816p pd=5.48u as=0 ps=0 w=2.4u l=0.4u
X120 POAVSS.t22 a_5042_918.t20 OOA POAVSS.t8 sg13_hv_nmos ad=0.408p pd=3.08u as=0.408p ps=3.08u w=1.2u l=0.6u
X121 POAVSS.t1 IOADISABLE IOAIREF POAVSS.t2 sg13_hv_nmos ad=0.114p pd=0.98u as=0.204p ps=1.88u w=0.6u l=0.6u
X122 POAVSS.t18 a_5042_918.t24 OOA POAVSS.t10 sg13_hv_nmos ad=0.408p pd=3.08u as=0.408p ps=3.08u w=1.2u l=0.6u
X123 POAVSS.t5 POAVSS.t5 POAVSS.t5 POAVSS.t130 sg13_hv_nmos ad=0.408p pd=3.08u as=0 ps=0 w=1.2u l=0.6u
X124 POAVSS.t1 a_3300_5486# a_3874_722# POAVSS.t51 sg13_hv_nmos ad=0.204p pd=1.88u as=0.114p ps=0.98u w=0.6u l=2.4u
X125 POAVSS.t7 a_5042_918.t18 OOA POAVSS.t6 sg13_hv_nmos ad=0.408p pd=3.08u as=0.408p ps=3.08u w=1.2u l=0.6u
X126 POAVSS.t26 a_5042_918.t22 OOA POAVSS.t6 sg13_hv_nmos ad=0.408p pd=3.08u as=0.408p ps=3.08u w=1.2u l=0.6u
X127 a_2414_722# a_1748_242# POAVSS.t46 POAVSS.t41 sg13_hv_nmos ad=0.114p pd=0.98u as=0.204p ps=1.88u w=0.6u l=2.4u
X128 OOA a_4548_5486.t21 POAVDD POAVDD sg13_hv_pmos ad=0.816p pd=5.48u as=0.816p ps=5.48u w=2.4u l=0.4u
X129 POAVSS.t1 a_1748_242# POAVSS.t1 POAVSS.t2 sg13_hv_nmos ad=0.204p pd=1.88u as=0 ps=0 w=0.6u l=2.4u
X130 POAVDD a_268_4130# a_576_4062# POAVDD sg13_hv_pmos ad=0.34p pd=2.68u as=0.34p ps=2.68u w=1u l=10u
X131 OOA a_4548_5486.t21 POAVDD POAVDD sg13_hv_pmos ad=0.816p pd=5.48u as=0.816p ps=5.48u w=2.4u l=0.4u
X132 POAVSS.t152 POAVSS.t152 POAVSS.t169 POAVSS.t137 sg13_hv_nmos ad=0.408p pd=3.08u as=0 ps=0 w=1.2u l=0.6u
X133 POAVDD POAVDD POAVDD POAVDD sg13_hv_pmos ad=0.816p pd=5.48u as=0 ps=0 w=2.4u l=0.4u
X134 a_5042_918.t2 a_3582_918# a_4548_5486.t10 POAVDD sg13_hv_pmos ad=0.816p pd=5.48u as=0.816p ps=5.48u w=2.4u l=0.4u
X135 POAVSS.t109 POAVSS.t106 POAVSS.t108 POAVSS.t107 sg13_hv_nmos ad=0.408p pd=3.08u as=0 ps=0 w=1.2u l=0.45u
X136 OOA a_4548_5486.t21 POAVDD POAVDD sg13_hv_pmos ad=0.816p pd=5.48u as=0.816p ps=5.48u w=2.4u l=0.4u
X137 a_3874_722# a_348_242# a_3300_5486# POAVSS.t52 sg13_hv_nmos ad=0.114p pd=0.98u as=0.204p ps=1.88u w=0.6u l=0.6u
X138 a_5796_5814# a_268_4130# a_3582_1058# POAVDD sg13_hv_pmos ad=0.228p pd=1.58u as=0.408p ps=3.08u w=1.2u l=0.6u
X139 a_4031_2546# a_2282_5050# POAVDD POAVDD sg13_hv_pmos ad=0.228p pd=1.58u as=0.408p ps=3.08u w=1.2u l=1.2u
X140 POAVDD POAVDD POAVDD POAVDD sg13_hv_pmos ad=0.816p pd=5.48u as=0 ps=0 w=2.4u l=0.4u
X141 POAVSS.t21 a_5042_918.t20 OOA POAVSS.t6 sg13_hv_nmos ad=0.408p pd=3.08u as=0.408p ps=3.08u w=1.2u l=0.6u
X142 POAVSS.t30 a_5042_918.t22 OOA POAVSS.t14 sg13_hv_nmos ad=0.408p pd=3.08u as=0.408p ps=3.08u w=1.2u l=0.6u
X143 OOA a_4548_5486.t23 POAVDD POAVDD sg13_hv_pmos ad=0.816p pd=5.48u as=0.816p ps=5.48u w=2.4u l=0.4u
X144 OOA a_5042_918.t21 POAVSS.t33 POAVSS.t10 sg13_hv_nmos ad=0.408p pd=3.08u as=0.408p ps=3.08u w=1.2u l=0.6u
X145 POAVDD a_4548_5486.t24 OOA POAVDD sg13_hv_pmos ad=0.816p pd=5.48u as=0.816p ps=5.48u w=2.4u l=0.4u
X146 POAVSS.t68 a_348_242# POAVSS.t67 POAVSS.t66 sg13_hv_nmos ad=0.136p pd=1.48u as=0 ps=0 w=0.4u l=10u
X147 POAVSS.t1 a_3300_5486# a_3874_722# POAVSS.t52 sg13_hv_nmos ad=0.204p pd=1.88u as=0.114p ps=0.98u w=0.6u l=2.4u
X148 OOA a_5042_918.t19 POAVSS.t83 POAVSS.t14 sg13_hv_nmos ad=0.408p pd=3.08u as=0.408p ps=3.08u w=1.2u l=0.6u
X149 POAVDD a_2282_5050# a_5796_5814# POAVDD sg13_hv_pmos ad=0.408p pd=3.08u as=0.228p ps=1.58u w=1.2u l=1.2u
X150 a_3300_5290# a_2282_5050# POAVDD POAVDD sg13_hv_pmos ad=0.228p pd=1.58u as=0.408p ps=3.08u w=1.2u l=1.2u
X151 POAVSS.t144 POAVSS.t144 POAVSS.t145 POAVSS.t137 sg13_hv_nmos ad=0.408p pd=3.08u as=0 ps=0 w=1.2u l=0.6u
X152 OOA a_5042_918.t17 POAVSS.t179 POAVSS.t10 sg13_hv_nmos ad=0.408p pd=3.08u as=0.408p ps=3.08u w=1.2u l=0.6u
X153 a_2414_918# a_348_242# a_2414_722# POAVSS.t39 sg13_hv_nmos ad=0.204p pd=1.88u as=0.114p ps=0.98u w=0.6u l=0.6u
X154 a_4548_5486.t11 a_3582_918# a_5042_918.t3 POAVDD sg13_hv_pmos ad=0.816p pd=5.48u as=0.816p ps=5.48u w=2.4u l=0.4u
X155 a_2282_5050# IOAIREF POAVSS.t1 POAVSS.t93 sg13_hv_nmos ad=0.204p pd=1.88u as=0.204p ps=1.88u w=0.6u l=2.4u
X156 POAVDD a_268_4130# POAVDD POAVDD sg13_hv_pmos ad=0.34p pd=2.68u as=0 ps=0 w=1u l=10u
X157 a_536_2242# a_348_242# POAVSS.t67 POAVSS.t69 sg13_hv_nmos ad=0.136p pd=1.48u as=0.136p ps=1.48u w=0.4u l=10u
X158 POAVSS.t25 a_5042_918.t20 OOA POAVSS.t14 sg13_hv_nmos ad=0.408p pd=3.08u as=0.408p ps=3.08u w=1.2u l=0.6u
X159 a_4548_5486.t7 a_268_4130# a_4031_2546# POAVDD sg13_hv_pmos ad=0.408p pd=3.08u as=0.228p ps=1.58u w=1.2u l=0.6u
X160 POAVDD a_268_4130# POAVDD POAVDD sg13_hv_pmos ad=0.408p pd=3.08u as=0 ps=0 w=1.2u l=0.6u
X161 OOA a_4548_5486.t23 POAVDD POAVDD sg13_hv_pmos ad=0.816p pd=5.48u as=0.816p ps=5.48u w=2.4u l=0.4u
X162 POAVDD POAVDD POAVDD POAVDD sg13_hv_pmos ad=0.816p pd=5.48u as=0 ps=0 w=2.4u l=0.4u
X163 a_7174_242# a_7174_242# POAVSS.t176 POAVSS.t78 sg13_hv_nmos ad=0.408p pd=3.08u as=0.408p ps=3.08u w=1.2u l=0.6u
X164 a_2414_722# a_1748_242# POAVSS.t46 POAVSS.t39 sg13_hv_nmos ad=0.114p pd=0.98u as=0.204p ps=1.88u w=0.6u l=2.4u
X165 POAVDD a_268_4130# POAVDD POAVDD sg13_hv_pmos ad=0.34p pd=2.68u as=0 ps=0 w=1u l=10u
X166 a_4031_2546# a_268_4130# a_4548_5486.t2 POAVDD sg13_hv_pmos ad=0.228p pd=1.58u as=0.408p ps=3.08u w=1.2u l=0.6u
X167 OOA a_4548_5486.t23 POAVDD POAVDD sg13_hv_pmos ad=0.816p pd=5.48u as=0.816p ps=5.48u w=2.4u l=0.4u
X168 POAVSS.t105 POAVSS.t99 POAVSS.t104 POAVSS.t103 sg13_hv_nmos ad=0.816p pd=5.48u as=0 ps=0 w=2.4u l=0.45u
X169 a_4548_5486.t4 a_268_4130# a_4031_2546# POAVDD sg13_hv_pmos ad=0.408p pd=3.08u as=0.228p ps=1.58u w=1.2u l=0.6u
X170 OOA a_4548_5486.t23 POAVDD POAVDD sg13_hv_pmos ad=0.816p pd=5.48u as=0.816p ps=5.48u w=2.4u l=0.4u
X171 a_5042_918.t11 a_348_242# a_5042_722# POAVSS.t57 sg13_hv_nmos ad=0.204p pd=1.88u as=0.114p ps=0.98u w=0.6u l=0.6u
X172 POAVDD a_2282_5050# a_4031_2546# POAVDD sg13_hv_pmos ad=0.408p pd=3.08u as=0.228p ps=1.58u w=1.2u l=1.2u
X173 a_3300_5290# a_268_4130# a_3300_5486# POAVDD sg13_hv_pmos ad=0.228p pd=1.58u as=0.408p ps=3.08u w=1.2u l=0.6u
X174 a_348_242# a_268_4130# a_2988_5290# POAVDD sg13_hv_pmos ad=0.408p pd=3.08u as=0.228p ps=1.58u w=1.2u l=0.6u
X175 a_3300_5290# a_2282_5050# POAVDD POAVDD sg13_hv_pmos ad=0.228p pd=1.58u as=0.408p ps=3.08u w=1.2u l=1.2u
X176 POAVDD POAVDD POAVDD POAVDD sg13_hv_pmos ad=0.816p pd=5.48u as=0 ps=0 w=2.4u l=0.4u
X177 OOA a_4548_5486.t17 POAVDD POAVDD sg13_hv_pmos ad=0.816p pd=5.48u as=0.816p ps=5.48u w=2.4u l=0.4u
X178 POAVSS.t9 a_5042_918.t18 OOA POAVSS.t8 sg13_hv_nmos ad=0.408p pd=3.08u as=0.408p ps=3.08u w=1.2u l=0.6u
X179 a_2676_5814# a_268_4130# a_2282_5050# POAVDD sg13_hv_pmos ad=0.228p pd=1.58u as=0.408p ps=3.08u w=1.2u l=0.6u
X180 POAVDD a_2282_5050# a_3300_5290# POAVDD sg13_hv_pmos ad=0.408p pd=3.08u as=0.228p ps=1.58u w=1.2u l=1.2u
X181 POAVDD POAVDD POAVDD POAVDD sg13_hv_pmos ad=0.816p pd=5.48u as=0 ps=0 w=2.4u l=0.4u
X182 POAVSS.t106 POAVSS.t106 POAVSS.t106 POAVSS.t107 sg13_hv_nmos ad=0.408p pd=3.08u as=0 ps=0 w=1.2u l=0.45u
X183 POAVSS.t123 POAVSS.t1 POAVSS.t122 POAVSS.t100 sg13_hv_nmos ad=0.816p pd=5.48u as=0 ps=0 w=2.4u l=0.45u
X184 OOA a_5042_918.t19 POAVSS.t7 POAVSS.t6 sg13_hv_nmos ad=0.408p pd=3.08u as=0.408p ps=3.08u w=1.2u l=0.6u
X185 a_5042_722# a_3300_5486# POAVSS.t60 POAVSS.t57 sg13_hv_nmos ad=0.114p pd=0.98u as=0.204p ps=1.88u w=0.6u l=2.4u
X186 POAVDD a_2282_5050# a_2676_5814# POAVDD sg13_hv_pmos ad=0.408p pd=3.08u as=0.228p ps=1.58u w=1.2u l=1.2u
X187 POAVSS.t152 POAVSS.t152 POAVSS.t165 POAVSS.t137 sg13_hv_nmos ad=0.408p pd=3.08u as=0 ps=0 w=1.2u l=0.6u
X188 a_1830_918# IOADISABLE POAVSS.t1 POAVSS.t2 sg13_hv_nmos ad=0.204p pd=1.88u as=0.114p ps=0.98u w=0.6u l=0.6u
X189 POAVDD a_4548_5486.t20 OOA POAVDD sg13_hv_pmos ad=0.816p pd=5.48u as=0.816p ps=5.48u w=2.4u l=0.4u
X190 OOA a_4548_5486.t21 POAVDD POAVDD sg13_hv_pmos ad=0.816p pd=5.48u as=0.816p ps=5.48u w=2.4u l=0.4u
X191 OOA a_4548_5486.t17 POAVDD POAVDD sg13_hv_pmos ad=0.816p pd=5.48u as=0.816p ps=5.48u w=2.4u l=0.4u
X192 POAVSS.t29 a_5042_918.t22 OOA POAVSS.t12 sg13_hv_nmos ad=0.408p pd=3.08u as=0.408p ps=3.08u w=1.2u l=0.6u
X193 OOA a_4548_5486.t17 POAVDD POAVDD sg13_hv_pmos ad=0.816p pd=5.48u as=0.816p ps=5.48u w=2.4u l=0.4u
X194 OOA a_5042_918.t23 POAVSS.t85 POAVSS.t8 sg13_hv_nmos ad=0.408p pd=3.08u as=0.408p ps=3.08u w=1.2u l=0.6u
X195 POAVDD a_268_4130# POAVDD POAVDD sg13_hv_pmos ad=0.408p pd=3.08u as=0 ps=0 w=1.2u l=0.6u
X196 POAVDD POAVDD POAVDD POAVDD sg13_hv_pmos ad=0.816p pd=5.48u as=0 ps=0 w=2.4u l=0.4u
X197 POAVSS.t98 POAVSS.t95 POAVSS.t97 POAVSS.t96 sg13_hv_nmos ad=0.408p pd=3.08u as=0 ps=0 w=1.2u l=0.45u
X198 POAVSS.t1 a_1748_242# POAVSS.t1 POAVSS.t2 sg13_hv_nmos ad=0.114p pd=0.98u as=0 ps=0 w=0.6u l=2.4u
X199 OOA a_4548_5486.t17 POAVDD POAVDD sg13_hv_pmos ad=0.816p pd=5.48u as=0.816p ps=5.48u w=2.4u l=0.4u
X200 POAVDD POAVDD POAVDD POAVDD sg13_hv_pmos ad=0.816p pd=5.48u as=0 ps=0 w=2.4u l=0.4u
X201 IOAIREF IOAIREF POAVSS.t1 POAVSS.t91 sg13_hv_nmos ad=0.204p pd=1.88u as=0.204p ps=1.88u w=0.6u l=2.4u
X202 a_3300_5486# a_348_242# a_3874_722# POAVSS.t53 sg13_hv_nmos ad=0.204p pd=1.88u as=0.114p ps=0.98u w=0.6u l=0.6u
X203 POAVDD a_4548_5486.t20 OOA POAVDD sg13_hv_pmos ad=0.816p pd=5.48u as=0.816p ps=5.48u w=2.4u l=0.4u
X204 OOA a_4548_5486.t19 POAVDD POAVDD sg13_hv_pmos ad=0.816p pd=5.48u as=0.816p ps=5.48u w=2.4u l=0.4u
X205 POAVSS.t139 POAVSS.t136 POAVSS.t138 POAVSS.t137 sg13_hv_nmos ad=0.408p pd=3.08u as=0 ps=0 w=1.2u l=0.6u
X206 POAVSS.t24 a_5042_918.t20 OOA POAVSS.t12 sg13_hv_nmos ad=0.408p pd=3.08u as=0.408p ps=3.08u w=1.2u l=0.6u
X207 POAVDD a_4548_5486.t20 OOA POAVDD sg13_hv_pmos ad=0.816p pd=5.48u as=0.816p ps=5.48u w=2.4u l=0.4u
X208 a_4031_2546# IOAP a_2414_918# POAVSS.t103 sg13_hv_nmos ad=0.816p pd=5.48u as=0.816p ps=5.48u w=2.4u l=0.45u
X209 OOA a_5042_918.t17 POAVSS.t180 POAVSS.t12 sg13_hv_nmos ad=0.408p pd=3.08u as=0.408p ps=3.08u w=1.2u l=0.6u
X210 a_5042_918.t0 IOADISABLE POAVSS.t5 POAVSS.t4 sg13_hv_nmos ad=0.204p pd=1.88u as=0.114p ps=0.98u w=0.6u l=0.6u
X211 OOA a_5042_918.t23 POAVSS.t26 POAVSS.t6 sg13_hv_nmos ad=0.408p pd=3.08u as=0.408p ps=3.08u w=1.2u l=0.6u
X212 a_3874_722# a_3300_5486# POAVSS.t60 POAVSS.t53 sg13_hv_nmos ad=0.114p pd=0.98u as=0.204p ps=1.88u w=0.6u l=2.4u
X213 POAVDD POAVDD POAVDD POAVDD sg13_hv_pmos ad=0.816p pd=5.48u as=0 ps=0 w=2.4u l=0.4u
X214 POAVDD a_4548_5486.t20 OOA POAVDD sg13_hv_pmos ad=0.816p pd=5.48u as=0.816p ps=5.48u w=2.4u l=0.4u
X215 a_4031_2546# a_2282_5050# POAVDD POAVDD sg13_hv_pmos ad=0.228p pd=1.58u as=0.408p ps=3.08u w=1.2u l=1.2u
X216 POAVDD a_2282_5050# POAVDD POAVDD sg13_hv_pmos ad=0.228p pd=1.58u as=0 ps=0 w=1.2u l=1.2u
X217 OOA a_4548_5486.t23 POAVDD POAVDD sg13_hv_pmos ad=0.816p pd=5.48u as=0.816p ps=5.48u w=2.4u l=0.4u
X218 OOA a_4548_5486.t19 POAVDD POAVDD sg13_hv_pmos ad=0.816p pd=5.48u as=0.816p ps=5.48u w=2.4u l=0.4u
X219 POAVSS.t5 POAVSS.t5 POAVSS.t60 POAVSS.t4 sg13_hv_nmos ad=0.114p pd=0.98u as=0 ps=0 w=0.6u l=2.4u
X220 OOA a_4548_5486.t19 POAVDD POAVDD sg13_hv_pmos ad=0.816p pd=5.48u as=0.816p ps=5.48u w=2.4u l=0.4u
X221 POAVSS.t152 POAVSS.t152 POAVSS.t157 POAVSS.t137 sg13_hv_nmos ad=0.408p pd=3.08u as=0 ps=0 w=1.2u l=0.6u
X222 a_4031_2546# a_268_4130# a_4548_5486.t1 POAVDD sg13_hv_pmos ad=0.228p pd=1.58u as=0.408p ps=3.08u w=1.2u l=0.6u
X223 a_4031_2546# a_2282_5050# POAVDD POAVDD sg13_hv_pmos ad=0.228p pd=1.58u as=0.408p ps=3.08u w=1.2u l=1.2u
X224 OOA a_5042_918.t19 POAVSS.t80 POAVSS.t8 sg13_hv_nmos ad=0.408p pd=3.08u as=0.408p ps=3.08u w=1.2u l=0.6u
X225 OOA a_5042_918.t23 POAVSS.t88 POAVSS.t14 sg13_hv_nmos ad=0.408p pd=3.08u as=0.408p ps=3.08u w=1.2u l=0.6u
X226 a_2988_5290# a_2282_5050# POAVDD POAVDD sg13_hv_pmos ad=0.228p pd=1.58u as=0.408p ps=3.08u w=1.2u l=1.2u
X227 OOA a_4548_5486.t19 POAVDD POAVDD sg13_hv_pmos ad=0.816p pd=5.48u as=0.816p ps=5.48u w=2.4u l=0.4u
X228 POAVDD a_2282_5050# a_4031_2546# POAVDD sg13_hv_pmos ad=0.408p pd=3.08u as=0.228p ps=1.58u w=1.2u l=1.2u
X229 a_3300_5290# a_268_4130# a_3300_5486# POAVDD sg13_hv_pmos ad=0.228p pd=1.58u as=0.408p ps=3.08u w=1.2u l=0.6u
X230 POAVDD POAVDD POAVDD POAVDD sg13_hv_pmos ad=0.816p pd=5.48u as=0 ps=0 w=2.4u l=0.4u
X231 a_3874_722# a_348_242# a_3300_5486# POAVSS.t53 sg13_hv_nmos ad=0.114p pd=0.98u as=0.204p ps=1.88u w=0.6u l=0.6u
X232 a_2414_918# a_348_242# a_2414_722# POAVSS.t36 sg13_hv_nmos ad=0.204p pd=1.88u as=0.114p ps=0.98u w=0.6u l=0.6u
X233 POAVSS.t1 POAVSS.t1 POAVSS.t1 POAVSS.t96 sg13_hv_nmos ad=0.408p pd=3.08u as=0 ps=0 w=1.2u l=0.45u
X234 POAVDD a_2282_5050# a_3300_5290# POAVDD sg13_hv_pmos ad=0.408p pd=3.08u as=0.228p ps=1.58u w=1.2u l=1.2u
X235 POAVSS.t1 a_3300_5486# a_3874_722# POAVSS.t53 sg13_hv_nmos ad=0.204p pd=1.88u as=0.114p ps=0.98u w=0.6u l=2.4u
X236 POAVSS.t1 a_348_242# POAVSS.t1 POAVSS.t38 sg13_hv_nmos ad=0.114p pd=0.98u as=0 ps=0 w=0.6u l=0.6u
X237 POAVDD POAVDD POAVDD POAVDD sg13_hv_pmos ad=0.816p pd=5.48u as=0 ps=0 w=2.4u l=0.4u
X238 POAVSS.t129 POAVSS.t1 POAVSS.t128 POAVSS.t107 sg13_hv_nmos ad=0.408p pd=3.08u as=0 ps=0 w=1.2u l=0.45u
X239 POAVSS.t17 a_5042_918.t24 OOA POAVSS.t8 sg13_hv_nmos ad=0.408p pd=3.08u as=0.408p ps=3.08u w=1.2u l=0.6u
X240 a_3300_5486# a_348_242# a_3874_722# POAVSS.t50 sg13_hv_nmos ad=0.204p pd=1.88u as=0.114p ps=0.98u w=0.6u l=0.6u
X241 OOA a_4548_5486.t17 POAVDD POAVDD sg13_hv_pmos ad=0.816p pd=5.48u as=0.816p ps=5.48u w=2.4u l=0.4u
X242 a_4548_5486.t12 a_3582_1058# a_5042_918.t15 POAVSS.t78 sg13_hv_nmos ad=0.408p pd=3.08u as=0.408p ps=3.08u w=1.2u l=0.6u
X243 POAVSS.t1 a_1748_242# POAVSS.t1 POAVSS.t38 sg13_hv_nmos ad=0.204p pd=1.88u as=0 ps=0 w=0.6u l=2.4u
X244 a_2414_722# a_1748_242# POAVSS.t44 POAVSS.t36 sg13_hv_nmos ad=0.114p pd=0.98u as=0.204p ps=1.88u w=0.6u l=2.4u
X245 a_3300_5486# a_268_4130# a_3300_5290# POAVDD sg13_hv_pmos ad=0.408p pd=3.08u as=0.228p ps=1.58u w=1.2u l=0.6u
X246 OOA a_5042_918.t17 POAVSS.t181 POAVSS.t14 sg13_hv_nmos ad=0.408p pd=3.08u as=0.408p ps=3.08u w=1.2u l=0.6u
X247 POAVDD a_2282_5050# POAVDD POAVDD sg13_hv_pmos ad=0.228p pd=1.58u as=0 ps=0 w=1.2u l=1.2u
X248 a_5042_918.t10 a_348_242# a_5042_722# POAVSS.t56 sg13_hv_nmos ad=0.204p pd=1.88u as=0.114p ps=0.98u w=0.6u l=0.6u
X249 a_3300_5290# a_268_4130# a_3300_5486# POAVDD sg13_hv_pmos ad=0.228p pd=1.58u as=0.408p ps=3.08u w=1.2u l=0.6u
X250 a_3874_722# a_3300_5486# POAVSS.t54 POAVSS.t50 sg13_hv_nmos ad=0.114p pd=0.98u as=0.204p ps=1.88u w=0.6u l=2.4u
X251 a_2414_722# a_348_242# a_2414_918# POAVSS.t36 sg13_hv_nmos ad=0.114p pd=0.98u as=0.204p ps=1.88u w=0.6u l=0.6u
X252 a_2414_918# IOAP a_4031_2546# POAVSS.t100 sg13_hv_nmos ad=0.816p pd=5.48u as=0.816p ps=5.48u w=2.4u l=0.45u
X253 POAVSS.t5 POAVSS.t5 POAVSS.t5 POAVSS.t130 sg13_hv_nmos ad=0.408p pd=3.08u as=0 ps=0 w=1.2u l=0.6u
X254 POAVDD a_2282_5050# a_3300_5290# POAVDD sg13_hv_pmos ad=0.408p pd=3.08u as=0.228p ps=1.58u w=1.2u l=1.2u
X255 POAVDD a_4548_5486.t20 OOA POAVDD sg13_hv_pmos ad=0.816p pd=5.48u as=0.816p ps=5.48u w=2.4u l=0.4u
X256 a_4548_5486.t14 a_3582_1058# a_5042_918.t13 POAVSS.t78 sg13_hv_nmos ad=0.408p pd=3.08u as=0.408p ps=3.08u w=1.2u l=0.6u
X257 POAVSS.t16 a_5042_918.t24 OOA POAVSS.t6 sg13_hv_nmos ad=0.408p pd=3.08u as=0.408p ps=3.08u w=1.2u l=0.6u
X258 POAVSS.t1 a_1748_242# a_2414_722# POAVSS.t36 sg13_hv_nmos ad=0.204p pd=1.88u as=0.114p ps=0.98u w=0.6u l=2.4u
X259 OOA a_5042_918.t21 POAVSS.t32 POAVSS.t8 sg13_hv_nmos ad=0.408p pd=3.08u as=0.408p ps=3.08u w=1.2u l=0.6u
X260 a_5042_722# a_3300_5486# POAVSS.t60 POAVSS.t56 sg13_hv_nmos ad=0.114p pd=0.98u as=0.204p ps=1.88u w=0.6u l=2.4u
X261 a_2414_722# a_348_242# a_2414_918# POAVSS.t41 sg13_hv_nmos ad=0.114p pd=0.98u as=0.204p ps=1.88u w=0.6u l=0.6u
X262 a_1120_4062# a_268_4130# a_268_4130# POAVDD sg13_hv_pmos ad=0.34p pd=2.68u as=0.34p ps=2.68u w=1u l=10u
X263 POAVSS.t5 POAVSS.t5 POAVSS.t5 POAVSS.t130 sg13_hv_nmos ad=0.408p pd=3.08u as=0 ps=0 w=1.2u l=0.6u
X264 a_5042_918.t4 a_3582_918# a_4548_5486.t8 POAVDD sg13_hv_pmos ad=0.816p pd=5.48u as=0.816p ps=5.48u w=2.4u l=0.4u
X265 POAVSS.t126 POAVSS.t1 POAVSS.t125 POAVSS.t103 sg13_hv_nmos ad=0.816p pd=5.48u as=0 ps=0 w=2.4u l=0.45u
X266 OOA a_5042_918.t23 POAVSS.t87 POAVSS.t12 sg13_hv_nmos ad=0.408p pd=3.08u as=0.408p ps=3.08u w=1.2u l=0.6u
X267 POAVSS.t1 a_1748_242# a_2414_722# POAVSS.t41 sg13_hv_nmos ad=0.204p pd=1.88u as=0.114p ps=0.98u w=0.6u l=2.4u
X268 a_2414_722# a_348_242# a_2414_918# POAVSS.t39 sg13_hv_nmos ad=0.114p pd=0.98u as=0.204p ps=1.88u w=0.6u l=0.6u
X269 OOA a_4548_5486.t19 POAVDD POAVDD sg13_hv_pmos ad=0.816p pd=5.48u as=0.816p ps=5.48u w=2.4u l=0.4u
X270 POAVSS.t20 a_5042_918.t24 OOA POAVSS.t14 sg13_hv_nmos ad=0.408p pd=3.08u as=0.408p ps=3.08u w=1.2u l=0.6u
X271 POAVSS.t5 POAVSS.t5 POAVSS.t5 POAVSS.t130 sg13_hv_nmos ad=0.408p pd=3.08u as=0 ps=0 w=1.2u l=0.6u
X272 POAVDD POAVDD POAVDD POAVDD sg13_hv_pmos ad=0.816p pd=5.48u as=0 ps=0 w=2.4u l=0.4u
X273 POAVSS.t1 a_1748_242# a_2414_722# POAVSS.t39 sg13_hv_nmos ad=0.204p pd=1.88u as=0.114p ps=0.98u w=0.6u l=2.4u
X274 OOA a_5042_918.t17 POAVSS.t177 POAVSS.t6 sg13_hv_nmos ad=0.408p pd=3.08u as=0.408p ps=3.08u w=1.2u l=0.6u
X275 OOA a_5042_918.t21 POAVSS.t21 POAVSS.t6 sg13_hv_nmos ad=0.408p pd=3.08u as=0.408p ps=3.08u w=1.2u l=0.6u
X276 POAVSS.t1 IOADISABLE a_3582_1058# POAVSS.t0 sg13_hv_nmos ad=0.114p pd=0.98u as=0.204p ps=1.88u w=0.6u l=0.6u
X277 POAVSS.t28 a_5042_918.t22 OOA POAVSS.t10 sg13_hv_nmos ad=0.408p pd=3.08u as=0.408p ps=3.08u w=1.2u l=0.6u
X278 a_2414_918# a_348_242# a_2414_722# POAVSS.t40 sg13_hv_nmos ad=0.204p pd=1.88u as=0.114p ps=0.98u w=0.6u l=0.6u
X279 a_268_4130# IOAIREF POAVSS.t1 POAVSS.t92 sg13_hv_nmos ad=0.204p pd=1.88u as=0.204p ps=1.88u w=0.6u l=2.4u
X280 POAVSS.t175 POAVSS.t173 POAVSS.t173 POAVSS.t137 sg13_hv_nmos ad=0.408p pd=3.08u as=0 ps=0 w=1.2u l=0.6u
X281 POAVSS.t1 a_1748_242# POAVSS.t1 POAVSS.t0 sg13_hv_nmos ad=0.204p pd=1.88u as=0 ps=0 w=0.6u l=2.4u
R0 POAVSS.n0 POAVSS.n42 109.98
R1 POAVSS.n154 POAVSS.n102 47.8971
R2 POAVSS.n155 POAVSS.n101 47.8971
R3 POAVSS.n157 POAVSS.n99 47.8971
R4 POAVSS.n159 POAVSS.n97 47.8971
R5 POAVSS.n161 POAVSS.n95 47.8971
R6 POAVSS.n169 POAVSS.n31 54.2951
R7 POAVSS.t73 POAVSS.n41 53.8003
R8 POAVSS.t39 POAVSS.n100 45.6163
R9 POAVSS.n52 POAVSS.t130 52.8659
R10 POAVSS.n103 POAVSS.t92 41.815
R11 POAVSS.n120 POAVSS.n78 41.815
R12 POAVSS.n137 POAVSS.n77 41.815
R13 POAVSS.n136 POAVSS.n75 41.815
R14 POAVSS.n122 POAVSS.n74 41.815
R15 POAVSS.n55 POAVSS.n73 41.815
R16 POAVSS.n135 POAVSS.n71 41.815
R17 POAVSS.n124 POAVSS.n70 41.815
R18 POAVSS.n134 POAVSS.n69 41.815
R19 POAVSS.n125 POAVSS.n68 41.815
R20 POAVSS.n133 POAVSS.n67 41.815
R21 POAVSS.n126 POAVSS.n66 41.815
R22 POAVSS.n132 POAVSS.n65 41.815
R23 POAVSS.n127 POAVSS.n64 41.815
R24 POAVSS.n130 POAVSS.n61 41.815
R25 POAVSS.n58 POAVSS.n60 41.815
R26 POAVSS.n37 POAVSS.t69 47.4872
R27 POAVSS.n158 POAVSS.t94 39.5342
R28 POAVSS.n1 POAVSS.t4 13.8023
R29 POAVSS.n128 POAVSS.t107 38.0137
R30 POAVSS.t71 POAVSS.n38 44.3316
R31 POAVSS.n175 POAVSS.n111 37.0862
R32 POAVSS.n163 POAVSS.n112 37.0862
R33 POAVSS.n162 POAVSS.n110 37.0862
R34 POAVSS.n149 POAVSS.n108 35.7329
R35 POAVSS.n150 POAVSS.n107 35.7329
R36 POAVSS.n153 POAVSS.n104 35.7329
R37 POAVSS.n49 POAVSS.t10 43.1422
R38 POAVSS.t38 POAVSS.n109 34.9726
R39 POAVSS.t72 POAVSS.n39 41.1747
R40 POAVSS.n116 POAVSS.n85 34.2124
R41 POAVSS.n141 POAVSS.n84 34.2124
R42 POAVSS.n140 POAVSS.n82 34.2124
R43 POAVSS.n118 POAVSS.n81 34.2124
R44 POAVSS.n139 POAVSS.n80 34.2124
R45 POAVSS.n119 POAVSS.t52 34.2124
R46 POAVSS.n138 POAVSS.n79 34.2124
R47 POAVSS.t91 POAVSS.n106 32.6918
R48 POAVSS.n131 POAVSS.t57 32.6918
R49 POAVSS.t40 POAVSS.n96 30.411
R50 POAVSS.n38 POAVSS.t70 34.8622
R51 POAVSS.n147 POAVSS.n31 34.5276
R52 POAVSS.n146 POAVSS.n94 28.1303
R53 POAVSS.n174 POAVSS.n93 28.1303
R54 POAVSS.n145 POAVSS.n92 28.1303
R55 POAVSS.n144 POAVSS.t0 28.1303
R56 POAVSS.n114 POAVSS.n90 28.1303
R57 POAVSS.n143 POAVSS.n89 28.1303
R58 POAVSS.n115 POAVSS.n88 28.1303
R59 POAVSS.n167 POAVSS.n86 28.1303
R60 POAVSS.n152 POAVSS.t36 26.6097
R61 POAVSS.n121 POAVSS.t53 26.6097
R62 POAVSS.t70 POAVSS.n37 31.7066
R63 POAVSS.t55 POAVSS.t103 25.0892
R64 POAVSS.t58 POAVSS.n59 24.3289
R65 POAVSS.n146 POAVSS.n93 23.5687
R66 POAVSS.n174 POAVSS.n92 23.5687
R67 POAVSS.n145 POAVSS.n91 23.5687
R68 POAVSS.n113 POAVSS.t0 23.5687
R69 POAVSS.n144 POAVSS.n90 23.5687
R70 POAVSS.n114 POAVSS.n89 23.5687
R71 POAVSS.n143 POAVSS.n88 23.5687
R72 POAVSS.n115 POAVSS.n87 23.5687
R73 POAVSS.n142 POAVSS.n86 23.5687
R74 POAVSS.n52 POAVSS.n0 112.853
R75 POAVSS.t8 POAVSS.n45 26.9354
R76 POAVSS.n47 POAVSS.t10 26.9342
R77 POAVSS.t100 POAVSS.n83 19.0071
R78 POAVSS.n41 POAVSS.t72 25.3935
R79 POAVSS.n160 POAVSS.t40 17.4866
R80 POAVSS.n173 POAVSS.n85 17.4866
R81 POAVSS.n116 POAVSS.n84 17.4866
R82 POAVSS.n117 POAVSS.n82 17.4866
R83 POAVSS.n140 POAVSS.n81 17.4866
R84 POAVSS.n118 POAVSS.n80 17.4866
R85 POAVSS.n139 POAVSS.t52 17.4866
R86 POAVSS.n119 POAVSS.n79 17.4866
R87 POAVSS.n138 POAVSS.n78 17.4866
R88 POAVSS.n129 POAVSS.t58 17.4866
R89 POAVSS.n50 POAVSS.t12 17.2107
R90 POAVSS.n5 POAVSS.n47 0.0013087
R91 POAVSS.n5 POAVSS.n49 0.00115497
R92 POAVSS.t5 POAVSS.t172 5.60899
R93 POAVSS.t176 POAVSS.n30 5.65569
R94 POAVSS.t177 POAVSS.n30 5.64762
R95 POAVSS.t178 POAVSS.n7 5.61594
R96 POAVSS.t179 POAVSS.n7 5.65658
R97 POAVSS.t180 POAVSS.n7 5.64762
R98 POAVSS.t181 POAVSS.n7 5.64762
R99 POAVSS.t175 POAVSS.n7 5.64762
R100 POAVSS.n29 POAVSS.n28 0.146626
R101 POAVSS.t12 POAVSS.n47 52.8685
R102 POAVSS.n19 POAVSS.n18 0.118472
R103 POAVSS.n45 POAVSS.n5 0.00107703
R104 POAVSS.n52 POAVSS.n5 0.00182688
R105 POAVSS.t132 POAVSS.t5 5.64519
R106 POAVSS.n21 POAVSS.n27 0.0942991
R107 POAVSS.n22 POAVSS.n21 0.0266263
R108 POAVSS.n22 POAVSS.t135 5.64519
R109 POAVSS.n27 POAVSS.t16 5.64519
R110 POAVSS.t17 POAVSS.n6 5.64519
R111 POAVSS.t18 POAVSS.n6 5.64519
R112 POAVSS.t19 POAVSS.n19 5.64519
R113 POAVSS.n29 POAVSS.n23 0.0942991
R114 POAVSS.n24 POAVSS.n23 0.0266263
R115 POAVSS.t20 POAVSS.n24 5.64519
R116 POAVSS.t138 POAVSS.n29 5.64519
R117 POAVSS.n5 POAVSS.t5 0.173504
R118 POAVSS.t1 POAVSS.t5 0.694277
R119 POAVSS.n0 POAVSS.n60 8.49717
R120 POAVSS.n0 POAVSS.n61 8.49692
R121 POAVSS.n0 POAVSS.n62 8.49667
R122 POAVSS.n0 POAVSS.n63 8.49643
R123 POAVSS.n0 POAVSS.n64 8.49618
R124 POAVSS.n0 POAVSS.n65 8.49593
R125 POAVSS.n0 POAVSS.n66 8.49688
R126 POAVSS.n0 POAVSS.n67 8.49569
R127 POAVSS.n0 POAVSS.n68 8.49544
R128 POAVSS.n0 POAVSS.n70 8.49519
R129 POAVSS.n0 POAVSS.n71 8.49867
R130 POAVSS.n0 POAVSS.n72 8.49495
R131 POAVSS.n0 POAVSS.n73 8.4947
R132 POAVSS.n0 POAVSS.n74 8.49446
R133 POAVSS.n0 POAVSS.n75 8.49422
R134 POAVSS.n0 POAVSS.n76 8.49397
R135 POAVSS.n0 POAVSS.n77 8.49373
R136 POAVSS.n0 POAVSS.n78 8.49348
R137 POAVSS.n0 POAVSS.n79 8.49324
R138 POAVSS.n0 POAVSS.t52 8.493
R139 POAVSS.n0 POAVSS.n80 8.49276
R140 POAVSS.n0 POAVSS.n81 8.49251
R141 POAVSS.n0 POAVSS.n82 8.49719
R142 POAVSS.n0 POAVSS.n83 8.49227
R143 POAVSS.n0 POAVSS.n85 8.49203
R144 POAVSS.n0 POAVSS.n87 8.49179
R145 POAVSS.n0 POAVSS.n88 8.49155
R146 POAVSS.n0 POAVSS.n89 8.49268
R147 POAVSS.n0 POAVSS.n90 8.49131
R148 POAVSS.n0 POAVSS.t0 8.49107
R149 POAVSS.n0 POAVSS.n91 8.49084
R150 POAVSS.n0 POAVSS.n93 8.4906
R151 POAVSS.n0 POAVSS.n95 8.49036
R152 POAVSS.n0 POAVSS.n96 8.49013
R153 POAVSS.n0 POAVSS.n97 8.48989
R154 POAVSS.n0 POAVSS.n98 8.48966
R155 POAVSS.n0 POAVSS.n99 8.48942
R156 POAVSS.n0 POAVSS.n100 8.48919
R157 POAVSS.n0 POAVSS.n101 8.48896
R158 POAVSS.n0 POAVSS.n102 8.49405
R159 POAVSS.n0 POAVSS.n104 8.48872
R160 POAVSS.n0 POAVSS.n105 8.48849
R161 POAVSS.n0 POAVSS.n106 8.48826
R162 POAVSS.n0 POAVSS.n107 8.49747
R163 POAVSS.n0 POAVSS.n108 8.49742
R164 POAVSS.n0 POAVSS.n109 8.48803
R165 POAVSS.n0 POAVSS.n110 8.4878
R166 POAVSS.n0 POAVSS.n112 8.48735
R167 POAVSS.n0 POAVSS.n111 8.48757
R168 POAVSS.n0 POAVSS.n2 2.45179
R169 POAVSS.n42 POAVSS.t74 54.7962
R170 POAVSS.n35 POAVSS.n36 0.125902
R171 POAVSS.n35 POAVSS.n4 0.0602603
R172 POAVSS.t75 POAVSS.n4 0.123341
R173 POAVSS.n35 POAVSS.n41 1.0239
R174 POAVSS.n35 POAVSS.n39 1.0239
R175 POAVSS.n35 POAVSS.n38 1.0239
R176 POAVSS.n35 POAVSS.n37 1.0239
R177 POAVSS.t1 POAVSS.n34 0.269272
R178 POAVSS.n176 POAVSS.n33 8.49685
R179 POAVSS.n33 POAVSS.n162 8.49826
R180 POAVSS.n33 POAVSS.n163 8.49925
R181 POAVSS.n56 POAVSS.n146 17.0005
R182 POAVSS.n56 POAVSS.n145 17.0005
R183 POAVSS.n56 POAVSS.n113 17.0005
R184 POAVSS.n56 POAVSS.n144 17.0005
R185 POAVSS.n56 POAVSS.n114 17.0005
R186 POAVSS.n56 POAVSS.n143 17.0005
R187 POAVSS.n56 POAVSS.n115 17.0005
R188 POAVSS.n56 POAVSS.n142 17.0005
R189 POAVSS.n56 POAVSS.n167 17.0005
R190 POAVSS.n56 POAVSS.n173 17.0005
R191 POAVSS.n26 POAVSS.n172 0.110745
R192 POAVSS.n56 POAVSS.n116 17.0005
R193 POAVSS.n56 POAVSS.n141 17.0005
R194 POAVSS.n56 POAVSS.n117 17.0005
R195 POAVSS.n26 POAVSS.n25 0.0846609
R196 POAVSS.n56 POAVSS.n140 17.0005
R197 POAVSS.n56 POAVSS.n26 2.80647
R198 POAVSS.n56 POAVSS.n118 17.0005
R199 POAVSS.n56 POAVSS.n139 17.0005
R200 POAVSS.n56 POAVSS.n119 17.0005
R201 POAVSS.n56 POAVSS.n138 17.0005
R202 POAVSS.n56 POAVSS.n120 17.0005
R203 POAVSS.n56 POAVSS.n137 17.0005
R204 POAVSS.n56 POAVSS.n121 17.0005
R205 POAVSS.n56 POAVSS.n136 17.0005
R206 POAVSS.n56 POAVSS.n122 17.0005
R207 POAVSS.n56 POAVSS.n55 8.50087
R208 POAVSS.n56 POAVSS.n123 17.0005
R209 POAVSS.n56 POAVSS.n135 17.0005
R210 POAVSS.n56 POAVSS.n124 17.0005
R211 POAVSS.n12 POAVSS.n32 0.275412
R212 POAVSS.n56 POAVSS.n134 17.0005
R213 POAVSS.n56 POAVSS.n125 17.0005
R214 POAVSS.n56 POAVSS.n133 17.0005
R215 POAVSS.n56 POAVSS.n126 17.0005
R216 POAVSS.n56 POAVSS.n132 17.0005
R217 POAVSS.n56 POAVSS.n127 17.0005
R218 POAVSS.n56 POAVSS.n131 17.0005
R219 POAVSS.n56 POAVSS.n128 17.0005
R220 POAVSS.n56 POAVSS.n13 0.700303
R221 POAVSS.n56 POAVSS.n130 17.0005
R222 POAVSS.n56 POAVSS.n58 8.50075
R223 POAVSS.n148 POAVSS.n57 0.0013607
R224 POAVSS.n148 POAVSS.n130 17.0005
R225 POAVSS.n148 POAVSS.n128 17.0005
R226 POAVSS.n148 POAVSS.t1 0.19552
R227 POAVSS.n148 POAVSS.n131 17.0005
R228 POAVSS.n148 POAVSS.n127 17.0005
R229 POAVSS.n148 POAVSS.n132 17.0005
R230 POAVSS.n148 POAVSS.n126 17.0005
R231 POAVSS.n148 POAVSS.n133 17.0005
R232 POAVSS.n148 POAVSS.n125 17.0005
R233 POAVSS.n148 POAVSS.n134 17.0005
R234 POAVSS.n148 POAVSS.n124 17.0005
R235 POAVSS.n148 POAVSS.n135 17.0005
R236 POAVSS.n148 POAVSS.n123 17.0005
R237 POAVSS.n57 POAVSS.n56 0.0012768
R238 POAVSS.n148 POAVSS.n122 17.0005
R239 POAVSS.n148 POAVSS.n136 17.0005
R240 POAVSS.n148 POAVSS.n121 17.0005
R241 POAVSS.n148 POAVSS.n137 17.0005
R242 POAVSS.n148 POAVSS.n120 17.0005
R243 POAVSS.n148 POAVSS.n138 17.0005
R244 POAVSS.n148 POAVSS.n119 17.0005
R245 POAVSS.n148 POAVSS.n139 17.0005
R246 POAVSS.n148 POAVSS.n118 17.0005
R247 POAVSS.n148 POAVSS.n140 17.0005
R248 POAVSS.n148 POAVSS.n117 17.0005
R249 POAVSS.n148 POAVSS.n141 17.0005
R250 POAVSS.n148 POAVSS.n116 17.0005
R251 POAVSS.n148 POAVSS.n142 17.0005
R252 POAVSS.n148 POAVSS.n115 17.0005
R253 POAVSS.n148 POAVSS.n143 17.0005
R254 POAVSS.n148 POAVSS.n114 17.0005
R255 POAVSS.n148 POAVSS.n144 17.0005
R256 POAVSS.n148 POAVSS.n113 17.0005
R257 POAVSS.n148 POAVSS.n145 17.0005
R258 POAVSS.n148 POAVSS.n146 17.0005
R259 POAVSS.t1 POAVSS.t95 0.263119
R260 POAVSS.n33 POAVSS.n151 8.499
R261 POAVSS.n33 POAVSS.n149 8.4995
R262 POAVSS.n11 POAVSS.n33 0.207149
R263 POAVSS.n11 POAVSS.t1 0.260733
R264 POAVSS.n33 POAVSS.n161 8.50118
R265 POAVSS.n33 POAVSS.n160 8.49909
R266 POAVSS.n33 POAVSS.n159 8.49875
R267 POAVSS.n33 POAVSS.n158 8.49884
R268 POAVSS.n33 POAVSS.n157 8.49859
R269 POAVSS.n33 POAVSS.n156 8.49834
R270 POAVSS.n33 POAVSS.n155 8.49809
R271 POAVSS.n33 POAVSS.n154 8.49784
R272 POAVSS.n33 POAVSS.n153 8.49759
R273 POAVSS.n33 POAVSS.n152 8.49734
R274 POAVSS.n33 POAVSS.n150 8.4971
R275 POAVSS.n0 POAVSS.n59 8.4974
R276 POAVSS.n0 POAVSS.n69 8.493
R277 POAVSS.n0 POAVSS.n84 8.49767
R278 POAVSS.n0 POAVSS.n86 8.49705
R279 POAVSS.n0 POAVSS.n92 8.49363
R280 POAVSS.n0 POAVSS.n94 8.49672
R281 POAVSS.n0 POAVSS.n103 8.49235
R282 POAVSS.t95 POAVSS.t98 5.64625
R283 POAVSS.t102 POAVSS.n25 2.79879
R284 POAVSS.n172 POAVSS.t102 17.0005
R285 POAVSS.t105 POAVSS.n32 2.38515
R286 POAVSS.t109 POAVSS.n12 5.64018
R287 POAVSS.t120 POAVSS.t1 5.65238
R288 POAVSS.t123 POAVSS.t1 2.40853
R289 POAVSS.t126 POAVSS.t1 2.41124
R290 POAVSS.t129 POAVSS.t1 5.66209
R291 POAVSS.t145 POAVSS.t152 5.64762
R292 POAVSS.n17 POAVSS.n14 0.0827767
R293 POAVSS.t152 POAVSS.t165 5.64762
R294 POAVSS.n175 POAVSS.n2 21.5771
R295 POAVSS.n163 POAVSS.n111 16.5707
R296 POAVSS.n162 POAVSS.n112 16.5707
R297 POAVSS.n176 POAVSS.n110 16.5707
R298 POAVSS.n149 POAVSS.n109 15.966
R299 POAVSS.n150 POAVSS.n108 15.966
R300 POAVSS.n151 POAVSS.n107 15.966
R301 POAVSS.n152 POAVSS.n106 15.966
R302 POAVSS.n153 POAVSS.n105 15.966
R303 POAVSS.t41 POAVSS.n94 15.2058
R304 POAVSS.t50 POAVSS.n87 15.2058
R305 POAVSS.t51 POAVSS.n83 15.2058
R306 POAVSS.n117 POAVSS.t100 15.2058
R307 POAVSS.t53 POAVSS.n76 15.2058
R308 POAVSS.t96 POAVSS.n91 14.4455
R309 POAVSS.n113 POAVSS.t96 13.6852
R310 POAVSS.n142 POAVSS.t50 12.925
R311 POAVSS.t69 POAVSS.n40 19.978
R312 POAVSS.n2 POAVSS.t2 11.8414
R313 POAVSS.n1 POAVSS.n0 0.03617
R314 POAVSS.n123 POAVSS.t55 11.4045
R315 POAVSS.t78 POAVSS.n46 13.3727
R316 POAVSS.t130 POAVSS.n46 17.2123
R317 POAVSS.n44 POAVSS.t78 13.3707
R318 POAVSS.n45 POAVSS.t6 52.8667
R319 POAVSS.n49 POAVSS.t8 43.1442
R320 POAVSS.t14 POAVSS.n48 13.3707
R321 POAVSS.t137 POAVSS.n51 52.8677
R322 POAVSS.n40 POAVSS.t66 6.54113
R323 POAVSS.t71 POAVSS.n39 38.0191
R324 POAVSS.t73 POAVSS.n36 13.6522
R325 POAVSS.n173 POAVSS.n166 10.2564
R326 POAVSS.n167 POAVSS.n166 10.2564
R327 POAVSS.t92 POAVSS.n104 9.88393
R328 POAVSS.n120 POAVSS.n77 9.88393
R329 POAVSS.n137 POAVSS.n76 9.88393
R330 POAVSS.n121 POAVSS.n75 9.88393
R331 POAVSS.n136 POAVSS.n74 9.88393
R332 POAVSS.n122 POAVSS.n73 9.88393
R333 POAVSS.n55 POAVSS.n72 9.88393
R334 POAVSS.n123 POAVSS.n71 9.88393
R335 POAVSS.n135 POAVSS.n70 9.88393
R336 POAVSS.n124 POAVSS.n69 9.88393
R337 POAVSS.n134 POAVSS.n68 9.88393
R338 POAVSS.n133 POAVSS.n66 9.88393
R339 POAVSS.n126 POAVSS.n65 9.88393
R340 POAVSS.n132 POAVSS.n64 9.88393
R341 POAVSS.n127 POAVSS.n63 9.88393
R342 POAVSS.n131 POAVSS.n62 9.88393
R343 POAVSS.n128 POAVSS.n61 9.88393
R344 POAVSS.n130 POAVSS.n60 9.88393
R345 POAVSS.n58 POAVSS.n59 9.88393
R346 POAVSS.n48 POAVSS.t137 17.2133
R347 POAVSS.t36 POAVSS.n105 9.12366
R348 POAVSS.t57 POAVSS.n63 9.12366
R349 POAVSS.n51 POAVSS.t152 0.831459
R350 POAVSS.n148 POAVSS.n174 8.501
R351 POAVSS.n8 POAVSS.n53 0.359611
R352 POAVSS.n5 POAVSS.n7 0.249175
R353 POAVSS.t5 POAVSS.n30 0.407882
R354 POAVSS.t44 POAVSS.n0 0.327831
R355 POAVSS.n5 POAVSS.n53 3.3895
R356 POAVSS.n15 POAVSS.n5 1.8272
R357 POAVSS.t144 POAVSS.n54 0.0387112
R358 POAVSS.n54 POAVSS.n5 4.22772
R359 POAVSS.n28 POAVSS.n5 1.15183
R360 POAVSS.n23 POAVSS.n5 8.49147
R361 POAVSS.n18 POAVSS.n5 1.34285
R362 POAVSS.n27 POAVSS.n6 0.200256
R363 POAVSS.n21 POAVSS.n5 8.49147
R364 POAVSS.n10 POAVSS.t95 0.298865
R365 POAVSS.n56 POAVSS.n10 1.58782
R366 POAVSS.n13 POAVSS.n12 0.131457
R367 POAVSS.n16 POAVSS.t85 5.64085
R368 POAVSS.n9 POAVSS.t86 5.64085
R369 POAVSS.n9 POAVSS.t87 5.64085
R370 POAVSS.t152 POAVSS.t88 5.64085
R371 POAVSS.n9 POAVSS.t27 5.63396
R372 POAVSS.n9 POAVSS.t28 5.63396
R373 POAVSS.t152 POAVSS.t29 5.63396
R374 POAVSS.t152 POAVSS.t30 5.63396
R375 POAVSS.t152 POAVSS.t153 5.64067
R376 POAVSS.t32 POAVSS.n17 5.64085
R377 POAVSS.t33 POAVSS.n14 5.64085
R378 POAVSS.t34 POAVSS.t152 5.64085
R379 POAVSS.t35 POAVSS.t152 5.64085
R380 POAVSS.t157 POAVSS.t152 5.63642
R381 POAVSS.t22 POAVSS.n14 5.63396
R382 POAVSS.t23 POAVSS.t152 5.63396
R383 POAVSS.t24 POAVSS.t152 5.63396
R384 POAVSS.t25 POAVSS.t152 5.63396
R385 POAVSS.t161 POAVSS.t152 5.59183
R386 POAVSS.t80 POAVSS.t7 5.64085
R387 POAVSS.t81 POAVSS.t7 5.64085
R388 POAVSS.t82 POAVSS.t7 5.64085
R389 POAVSS.t83 POAVSS.t152 5.64085
R390 POAVSS.t9 POAVSS.t7 5.63396
R391 POAVSS.t11 POAVSS.t7 5.63396
R392 POAVSS.t13 POAVSS.t152 5.63396
R393 POAVSS.t15 POAVSS.t152 5.63396
R394 POAVSS.t169 POAVSS.t152 5.64067
R395 POAVSS.t68 POAVSS.n43 0.739748
R396 POAVSS.n35 POAVSS.n43 0.298199
R397 POAVSS.n33 POAVSS.n34 1.14065
R398 POAVSS.t94 POAVSS.n98 8.3634
R399 POAVSS.n147 POAVSS.t41 8.3634
R400 POAVSS.t74 POAVSS.n36 13.6522
R401 POAVSS.t56 POAVSS.n67 6.08261
R402 POAVSS.n183 POAVSS.n30 6.0005
R403 POAVSS.n185 POAVSS.t60 6.0005
R404 POAVSS.n177 POAVSS.t46 6.0005
R405 POAVSS.n179 POAVSS.n3 6.0005
R406 POAVSS.n175 POAVSS.n33 1.4157
R407 POAVSS.n169 POAVSS.n33 1.41721
R408 POAVSS.n6 POAVSS.n5 0.737689
R409 POAVSS.n56 POAVSS.n171 5.64706
R410 POAVSS.n56 POAVSS.n168 5.64706
R411 POAVSS.n56 POAVSS.t1 0.940195
R412 POAVSS.t103 POAVSS.n72 5.32234
R413 POAVSS.n24 POAVSS.n18 0.285044
R414 POAVSS.n22 POAVSS.t5 0.230547
R415 POAVSS.n154 POAVSS.n103 3.80182
R416 POAVSS.n155 POAVSS.n102 3.80182
R417 POAVSS.n157 POAVSS.n100 3.80182
R418 POAVSS.n158 POAVSS.n99 3.80182
R419 POAVSS.n159 POAVSS.n98 3.80182
R420 POAVSS.n160 POAVSS.n97 3.80182
R421 POAVSS.n161 POAVSS.n96 3.80182
R422 POAVSS.n169 POAVSS.n95 3.80182
R423 POAVSS.n125 POAVSS.t56 3.80182
R424 POAVSS.t107 POAVSS.n62 3.80182
R425 POAVSS.n0 POAVSS.n31 1.05304
R426 POAVSS.n148 POAVSS.n166 3.37331
R427 POAVSS.n42 POAVSS.n35 0.0104781
R428 POAVSS.n35 POAVSS.n40 0.112312
R429 POAVSS.n51 POAVSS.n5 0.00101285
R430 POAVSS.n5 POAVSS.n48 0.0010659
R431 POAVSS.n44 POAVSS.t6 17.2127
R432 POAVSS.n5 POAVSS.n44 0.0010659
R433 POAVSS.t14 POAVSS.n50 13.3728
R434 POAVSS.n50 POAVSS.n5 0.00100934
R435 POAVSS.n46 POAVSS.n5 0.00100618
R436 POAVSS.n179 POAVSS.t67 3.18024
R437 POAVSS.n151 POAVSS.t91 3.04155
R438 POAVSS.n156 POAVSS.t93 3.04155
R439 POAVSS.t1 POAVSS.n180 3.0005
R440 POAVSS.n8 POAVSS.n7 0.283519
R441 POAVSS.t5 POAVSS.n20 3.0005
R442 POAVSS.t54 POAVSS.n164 3.0005
R443 POAVSS.n156 POAVSS.t39 2.28129
R444 POAVSS.n141 POAVSS.t51 2.28129
R445 POAVSS.n178 POAVSS.n35 1.81925
R446 POAVSS.n182 POAVSS.n7 1.76609
R447 POAVSS.n6 POAVSS.n184 1.76569
R448 POAVSS.t7 POAVSS.n182 1.5005
R449 POAVSS.t21 POAVSS.n181 1.5005
R450 POAVSS.n184 POAVSS.t26 1.5005
R451 POAVSS.t1 POAVSS.t106 0.44892
R452 POAVSS.t101 POAVSS.t97 1.23312
R453 POAVSS.t1 POAVSS.t125 0.358604
R454 POAVSS.t104 POAVSS.t108 1.2323
R455 POAVSS.n0 POAVSS.t47 0.909488
R456 POAVSS.n57 POAVSS.n129 0.811821
R457 POAVSS.n165 POAVSS.n0 0.84963
R458 POAVSS.t68 POAVSS.t75 1.02291
R459 POAVSS.n148 POAVSS.n147 0.810024
R460 POAVSS.n176 POAVSS.t38 0.789558
R461 POAVSS.t93 POAVSS.n101 0.760764
R462 POAVSS.n170 POAVSS.t104 0.621207
R463 POAVSS.t1 POAVSS.t122 0.358567
R464 POAVSS.n170 POAVSS.t101 0.620732
R465 POAVSS.n177 POAVSS.n164 0.359977
R466 POAVSS.n185 POAVSS.n20 0.357389
R467 POAVSS.n180 POAVSS.n177 0.355951
R468 POAVSS.n185 POAVSS.n164 0.35135
R469 POAVSS.t60 POAVSS.t5 0.437386
R470 POAVSS.t47 POAVSS.t54 0.318411
R471 POAVSS.n8 POAVSS.n183 1.49852
R472 POAVSS.n165 POAVSS.t60 0.300853
R473 POAVSS.t44 POAVSS.t46 0.299423
R474 POAVSS.t46 POAVSS.t47 0.296066
R475 POAVSS.n165 POAVSS.t54 0.294748
R476 POAVSS.t108 POAVSS.t106 0.28608
R477 POAVSS.t97 POAVSS.t95 0.285738
R478 POAVSS.n183 POAVSS.n20 0.269389
R479 POAVSS.t1 POAVSS.n3 0.410769
R480 POAVSS.n182 POAVSS.n181 0.260536
R481 POAVSS.n184 POAVSS.n181 0.26014
R482 POAVSS.n178 POAVSS.n3 0.257306
R483 POAVSS.n180 POAVSS.n179 0.202958
R484 POAVSS.t90 POAVSS.n34 0.553004
R485 POAVSS.n178 POAVSS.t67 0.184067
R486 POAVSS.t99 POAVSS.n170 0.1505
R487 POAVSS.n172 POAVSS.n10 0.290258
R488 POAVSS.t106 POAVSS.n13 0.350284
R489 POAVSS.t26 POAVSS.n16 0.103122
R490 POAVSS.n17 POAVSS.t21 0.103122
R491 POAVSS.t173 POAVSS.n15 0.223394
R492 POAVSS.t136 POAVSS.t139 0.0762589
R493 POAVSS.t139 POAVSS.n54 0.0387112
R494 POAVSS.n171 POAVSS.t99 0.0751008
R495 POAVSS.t99 POAVSS.n168 0.074765
R496 POAVSS.t136 POAVSS.n28 0.149876
R497 POAVSS.n32 POAVSS.n168 0.163254
R498 POAVSS.n25 POAVSS.n171 0.159424
R499 POAVSS.n53 POAVSS.t173 0.0347757
R500 POAVSS.n43 POAVSS.t67 0.698855
R501 POAVSS.n11 POAVSS.t90 1.23564
R502 POAVSS.n14 POAVSS.t152 1.19985
R503 POAVSS.t7 POAVSS.t152 1.17594
R504 POAVSS.t1 POAVSS.n4 0.338001
R505 POAVSS.t144 POAVSS.t152 0.904359
R506 POAVSS.t1 POAVSS.n0 0.294478
R507 POAVSS.t1 POAVSS.t128 0.751079
R508 POAVSS.n15 POAVSS.t152 0.714012
R509 POAVSS.t1 POAVSS.t119 0.705513
R510 POAVSS.n9 POAVSS.t152 0.660861
R511 POAVSS.n16 POAVSS.n9 0.660861
R512 POAVSS.n19 POAVSS.n6 0.65111
R513 POAVSS.n7 POAVSS.n30 0.647898
R514 POAVSS.n1 POAVSS.n129 17.3854
R515 a_5042_918.n6 a_5042_918.t0 17.3638
R516 a_5042_918.n1 a_5042_918.t14 5.64411
R517 a_5042_918.t16 a_5042_918.n4 5.64411
R518 a_5042_918.n8 a_5042_918.t5 17.0005
R519 a_5042_918.n9 a_5042_918.t6 17.0005
R520 a_5042_918.n7 a_5042_918.t7 17.0005
R521 a_5042_918.n6 a_5042_918.t8 17.0005
R522 a_5042_918.n8 a_5042_918.t9 17.0005
R523 a_5042_918.n9 a_5042_918.t10 17.0005
R524 a_5042_918.n7 a_5042_918.t11 17.0005
R525 a_5042_918.n6 a_5042_918.t12 17.0005
R526 a_5042_918.n0 a_5042_918.t13 5.64085
R527 a_5042_918.n3 a_5042_918.t15 5.64085
R528 a_5042_918.n13 a_5042_918.t17 15.4352
R529 a_5042_918.n11 a_5042_918.t24 15.4352
R530 a_5042_918.n14 a_5042_918.t19 15.0005
R531 a_5042_918.n13 a_5042_918.t18 15.0005
R532 a_5042_918.n17 a_5042_918.t21 15.0005
R533 a_5042_918.n16 a_5042_918.t20 15.0005
R534 a_5042_918.n11 a_5042_918.t23 15.0005
R535 a_5042_918.n12 a_5042_918.t22 15.0005
R536 a_5042_918.n1 a_5042_918.n0 0.0316692
R537 a_5042_918.n3 a_5042_918.n4 0.0316692
R538 a_5042_918.n19 a_5042_918.n18 6.19872
R539 a_5042_918.n5 a_5042_918.n10 4.84654
R540 a_5042_918.n19 a_5042_918.t3 3.52107
R541 a_5042_918.n19 a_5042_918.t4 3.51945
R542 a_5042_918.t1 a_5042_918.n20 2.43102
R543 a_5042_918.n20 a_5042_918.t2 2.43083
R544 a_5042_918.n18 a_5042_918.n5 0.6429
R545 a_5042_918.n14 a_5042_918.n13 0.435199
R546 a_5042_918.n17 a_5042_918.n16 0.435199
R547 a_5042_918.n12 a_5042_918.n11 0.435199
R548 a_5042_918.n9 a_5042_918.n8 0.196354
R549 a_5042_918.n7 a_5042_918.n6 0.196354
R550 a_5042_918.n20 a_5042_918.n19 0.169653
R551 a_5042_918.n15 a_5042_918.n0 0.134646
R552 a_5042_918.n3 a_5042_918.n2 0.134646
R553 a_5042_918.n15 a_5042_918.n14 0.109175
R554 a_5042_918.n16 a_5042_918.n15 0.109175
R555 a_5042_918.n2 a_5042_918.n17 0.109175
R556 a_5042_918.n2 a_5042_918.n12 0.109175
R557 a_5042_918.n10 a_5042_918.n9 0.0984268
R558 a_5042_918.n10 a_5042_918.n7 0.0984268
R559 a_5042_918.n4 a_5042_918.n18 4.56255
R560 a_5042_918.n1 a_5042_918.n5 4.56255
R561 a_4548_5486.n3 a_4548_5486.t1 5.65053
R562 a_4548_5486.n1 a_4548_5486.t17 15.3822
R563 a_4548_5486.n0 a_4548_5486.t24 15.3822
R564 a_4548_5486.n1 a_4548_5486.t19 15.0005
R565 a_4548_5486.n1 a_4548_5486.t18 15.0005
R566 a_4548_5486.n0 a_4548_5486.t21 15.0005
R567 a_4548_5486.n1 a_4548_5486.t20 15.0005
R568 a_4548_5486.n0 a_4548_5486.t23 15.0005
R569 a_4548_5486.n0 a_4548_5486.t22 15.0005
R570 a_4548_5486.n5 a_4548_5486.t16 13.5281
R571 a_4548_5486.n2 a_4548_5486.n5 10.6488
R572 a_4548_5486.t11 a_4548_5486.n1 2.46285
R573 a_4548_5486.t8 a_4548_5486.n0 2.46285
R574 a_4548_5486.n3 a_4548_5486.t2 5.64473
R575 a_4548_5486.t5 a_4548_5486.n3 5.64454
R576 a_4548_5486.n4 a_4548_5486.t12 6.53461
R577 a_4548_5486.n4 a_4548_5486.t15 6.53461
R578 a_4548_5486.n3 a_4548_5486.t6 6.12961
R579 a_4548_5486.n2 a_4548_5486.n3 6.06681
R580 a_4548_5486.n1 a_4548_5486.t10 2.40275
R581 a_4548_5486.t9 a_4548_5486.n0 2.40275
R582 a_4548_5486.n3 a_4548_5486.t3 5.66867
R583 a_4548_5486.n3 a_4548_5486.t4 5.66867
R584 a_4548_5486.n4 a_4548_5486.t13 5.66867
R585 a_4548_5486.n3 a_4548_5486.t0 5.66811
R586 a_4548_5486.n3 a_4548_5486.t7 5.66811
R587 a_4548_5486.n4 a_4548_5486.t14 5.66811
R588 a_4548_5486.n5 a_4548_5486.n4 5.18849
R589 a_4548_5486.n2 a_4548_5486.n0 2.1244
R590 a_4548_5486.n1 a_4548_5486.n0 1.8268
C0 a_5042_722# a_3300_5486# 0.75459f
C1 a_3582_918# POAVDD 1.98398f
C2 a_3300_5290# a_1748_242# 0.59513f
C3 a_2988_5814# a_3300_5290# 0.02411f
C4 a_268_4130# POAVDD 15.8426f
C5 a_3300_5290# a_4031_2546# 2.09149f
C6 a_3582_918# a_1830_918# 0.04127f
C7 a_348_242# a_3300_5486# 1.52267f
C8 a_2414_722# a_348_242# 0.39753f
C9 a_1830_918# a_268_4130# 0.46873f
C10 a_2988_5290# a_3300_5290# 0.02193f
C11 a_2414_918# a_3300_5486# 0.40288f
C12 a_2414_918# a_2414_722# 0.90398f
C13 a_268_4130# IOAIREF 0.27061f
C14 a_576_4062# POAVDD 0.57999f
C15 a_348_242# a_1748_242# 3.72344f
C16 a_2414_918# a_1748_242# 0.40481f
C17 a_3300_5290# POAVDD 0.69811f
C18 a_2414_918# a_4031_2546# 0.80877f
C19 IOADISABLE a_3582_1058# 0.12604f
C20 a_2282_5050# a_3582_1058# 0.05868f
C21 a_2676_5814# a_2988_5814# 0.01923f
C22 a_3300_5290# IOAP 0.03491f
C23 a_348_242# a_2988_5290# 0.09967f
C24 IOADISABLE a_840_2242# 0.03388f
C25 a_4031_2546# a_5796_5814# 0.02193f
C26 a_1830_918# a_3300_5290# 0.1462f
C27 a_3300_5290# IOAM 0.15075f
C28 a_7427_6047# POAVDD 0.6672f
C29 a_848_4062# a_1120_4062# 1.11545f
C30 a_348_242# POAVDD 0.14381f
C31 a_3582_918# a_3874_722# 0.01099f
C32 POAVDD a_5796_5814# 0.07683f
C33 a_1830_918# a_348_242# 0.66318f
C34 a_2414_918# IOAP 0.45489f
C35 a_2676_5814# POAVDD 0.07806f
C36 a_7174_242# a_3582_1058# 0.19362f
C37 a_348_242# IOAIREF 0.11176f
C38 a_2414_918# IOAM 0.36016f
C39 a_536_2242# a_688_2242# 1.16394f
C40 IOADISABLE a_3300_5486# 0.29628f
C41 a_2282_5050# a_3300_5486# 0.09253f
C42 a_2414_722# IOADISABLE 0.07646f
C43 a_576_4062# a_268_4130# 1.59047f
C44 IOADISABLE a_1748_242# 0.6805f
C45 a_3582_918# a_5042_722# 0.01059f
C46 a_2282_5050# a_1748_242# 0.22878f
C47 a_268_4130# a_3300_5290# 0.38209f
C48 a_2282_5050# a_2988_5814# 0.03927f
C49 a_3582_722# a_1748_242# 0.02169f
C50 a_3300_5486# a_3582_1058# 0.57059f
C51 a_2282_5050# a_4031_2546# 0.55257f
C52 a_3582_918# a_7427_6047# 0.38061f
C53 a_3874_722# a_5042_722# 0.01629f
C54 a_2282_5050# a_2988_5290# 0.04673f
C55 a_3582_918# a_348_242# 0.0276f
C56 a_348_242# a_536_2242# 0.90876f
C57 a_3582_918# a_2414_918# 0.01232f
C58 a_4031_2546# a_3582_1058# 0.03403f
C59 a_268_4130# a_348_242# 0.74808f
C60 POAVDD IOADISABLE 0.99904f
C61 a_348_242# a_3874_722# 0.39887f
C62 a_2122_722# a_1748_242# 0.08378f
C63 a_2282_5050# POAVDD 8.29752f
C64 POAVDD OOA 19.8709f
C65 a_2414_918# a_3874_722# 0.13855f
C66 a_268_4130# a_5796_5814# 0.02522f
C67 a_1120_4062# POAVDD 0.32203f
C68 a_268_4130# a_2676_5814# 0.02549f
C69 a_1830_918# IOADISABLE 2.31907f
C70 a_1830_918# a_2282_5050# 0.16437f
C71 a_348_242# a_688_2242# 0.77912f
C72 IOAIREF IOADISABLE 0.04218f
C73 POAVDD a_3582_1058# 1.62487f
C74 a_848_4062# POAVDD 0.26847f
C75 a_2282_5050# IOAIREF 0.03527f
C76 a_1748_242# a_3300_5486# 0.40412f
C77 a_992_2242# a_348_242# 1.41361f
C78 a_2414_722# a_1748_242# 0.90039f
C79 a_348_242# a_5042_722# 0.35528f
C80 a_2414_918# a_3300_5290# 0.82498f
C81 a_4031_2546# a_3300_5486# 0.53483f
C82 a_2988_5814# a_1748_242# 0.08089f
C83 a_4031_2546# a_1748_242# 0.03854f
C84 a_3582_918# IOADISABLE 1.99901f
C85 a_2414_918# a_348_242# 0.85453f
C86 a_3582_918# OOA 0.25556f
C87 POAVDD a_3300_5486# 0.51419f
C88 a_3582_918# a_3582_722# 0.0559f
C89 a_268_4130# IOADISABLE 0.25528f
C90 a_268_4130# a_2282_5050# 1.63989f
C91 a_3874_722# IOADISABLE 0.01002f
C92 POAVDD a_1748_242# 0.16396f
C93 a_1120_4062# a_268_4130# 1.92026f
C94 a_2988_5814# POAVDD 0.05918f
C95 a_1830_918# a_3300_5486# 0.27905f
C96 a_3582_918# a_3582_1058# 4.48416f
C97 POAVDD a_4031_2546# 0.80625f
C98 a_268_4130# a_3582_1058# 0.08309f
C99 a_848_4062# a_268_4130# 1.42543f
C100 a_1830_918# a_1748_242# 0.05618f
C101 IOADISABLE a_688_2242# 0.0154f
C102 a_3874_722# a_3582_1058# 0.3829f
C103 IOAIREF a_1748_242# 0.72421f
C104 IOAP a_4031_2546# 0.1044f
C105 a_2988_5290# POAVDD 0.07669f
C106 a_3582_918# a_7174_242# 0.09762f
C107 a_1830_918# a_4031_2546# 0.14159f
C108 IOAM a_4031_2546# 0.08377f
C109 a_992_2242# IOADISABLE 0.13387f
C110 a_2282_5050# a_3300_5290# 0.53342f
C111 a_5042_722# IOADISABLE 0.04695f
C112 a_576_4062# a_848_4062# 1.11545f
C113 a_688_2242# a_840_2242# 1.16394f
C114 a_3582_918# a_3300_5486# 0.44908f
C115 a_5042_722# a_3582_1058# 0.27219f
C116 a_992_2242# a_840_2242# 1.16394f
C117 a_348_242# IOADISABLE 1.89542f
C118 a_1830_918# POAVDD 2.31432f
C119 a_2282_5050# a_348_242# 1.1682f
C120 a_268_4130# a_3300_5486# 0.36617f
C121 a_2414_918# IOADISABLE 0.07302f
C122 a_3582_918# a_1748_242# 0.03051f
C123 a_3582_722# a_348_242# 0.0128f
C124 a_3874_722# a_3300_5486# 1.45523f
C125 IOAM IOAP 0.48002f
C126 a_268_4130# a_1748_242# 0.06825f
C127 a_2282_5050# a_5796_5814# 0.03571f
C128 a_3582_918# a_4031_2546# 0.08025f
C129 a_268_4130# a_2988_5814# 0.02526f
C130 a_2282_5050# a_2676_5814# 0.14162f
C131 a_1830_918# IOAIREF 0.80747f
C132 a_348_242# a_3582_1058# 0.15803f
C133 a_268_4130# a_4031_2546# 0.39934f
C134 a_348_242# a_840_2242# 0.77964f
C135 a_2414_918# a_3582_1058# 0.0269f
C136 a_5796_5814# a_3582_1058# 0.07035f
C137 a_268_4130# a_2988_5290# 0.02527f
C138 a_3300_5290# a_3300_5486# 1.81337f
C139 a_348_242# a_2122_722# 0.0161f
C140 OOA 0 0.12335p
C141 a_3582_722# 0 0.02208f
C142 a_2122_722# 0 0.03037f
C143 a_5042_722# 0 0.63237f
C144 a_3874_722# 0 5.67118f
C145 a_2414_722# 0 4.88662f
C146 a_2414_918# 0 2.03531f
C147 a_992_2242# 0 0.28772f
C148 a_840_2242# 0 0.19663f
C149 a_688_2242# 0 0.20652f
C150 a_536_2242# 0 0.60909f
C151 a_7427_6047# 0 0.54733f
C152 a_4031_2546# 0 2.57907f
C153 a_3300_5290# 0 2.6237f
C154 a_1120_4062# 0 0.28995f
C155 a_848_4062# 0 0.28835f
C156 a_4548_5486.n0 0 4.46969f
C157 a_4548_5486.n1 0 4.46969f
C158 a_4548_5486.n2 0 0.45631p
C159 a_4548_5486.n3 0 7.42107f
C160 a_4548_5486.n4 0 5.71468f
C161 a_4548_5486.t6 0 0.3959f
C162 a_4548_5486.t10 0 0.79988f
C163 a_4548_5486.t7 0 0.39822f
C164 a_4548_5486.t3 0 0.39827f
C165 a_4548_5486.t2 0 0.3959f
C166 a_4548_5486.t5 0 0.3959f
C167 a_4548_5486.t0 0 0.39822f
C168 a_4548_5486.t4 0 0.39827f
C169 a_4548_5486.t1 0 0.3959f
C170 a_4548_5486.t8 0 0.81029f
C171 a_4548_5486.t9 0 2.34328f
C172 a_4548_5486.t16 0 1.0127f
C173 a_4548_5486.t14 0 0.39822f
C174 a_4548_5486.t13 0 0.39827f
C175 a_4548_5486.t12 0 0.50632f
C176 a_4548_5486.t15 0 0.50632f
C177 a_4548_5486.n5 0 8.34902f
C178 a_4548_5486.t11 0 0.81029f
C179 a_5042_918.n0 0 0.58368f
C180 a_5042_918.n1 0 0.65462f
C181 a_5042_918.n2 0 0.73866f
C182 a_5042_918.n3 0 0.58368f
C183 a_5042_918.n4 0 0.65462f
C184 a_5042_918.n5 0 0.2264p
C185 a_5042_918.t2 0 0.82281f
C186 a_5042_918.t3 0 1.05965f
C187 a_5042_918.t4 0 1.05967f
C188 a_5042_918.t0 0 0.20813f
C189 a_5042_918.t12 0 0.20029f
C190 a_5042_918.t8 0 0.20029f
C191 a_5042_918.n6 0 1.38298f
C192 a_5042_918.t11 0 0.20029f
C193 a_5042_918.t7 0 0.20029f
C194 a_5042_918.n7 0 0.88156f
C195 a_5042_918.t10 0 0.20029f
C196 a_5042_918.t9 0 0.20029f
C197 a_5042_918.t5 0 0.20029f
C198 a_5042_918.n8 0 0.82923f
C199 a_5042_918.t6 0 0.20029f
C200 a_5042_918.n9 0 0.88156f
C201 a_5042_918.n10 0 1.47655f
C202 a_5042_918.n11 0 1.04439f
C203 a_5042_918.n12 0 0.41764f
C204 a_5042_918.n13 0 1.05231f
C205 a_5042_918.n14 0 0.41764f
C206 a_5042_918.t14 0 0.40112f
C207 a_5042_918.t13 0 0.40058f
C208 a_5042_918.n15 0 0.73866f
C209 a_5042_918.n16 0 0.41764f
C210 a_5042_918.n17 0 0.41764f
C211 a_5042_918.t15 0 0.40058f
C212 a_5042_918.t16 0 0.40112f
C213 a_5042_918.n18 0 0.2277p
C214 a_5042_918.n19 0 5.28095f
C215 a_5042_918.n20 0 1.63813f
C216 a_5042_918.t1 0 2.36637f
C217 POAVSS.t122 0 0.15803f
C218 POAVSS.t75 0 6.57875f
C219 POAVSS.t27 0 3.40196f
C220 POAVSS.t46 0 4.58033f
C221 POAVSS.t123 0 0.15803f
C222 POAVSS.t120 0 3.28937f
C223 POAVSS.t119 0 3.28937f
C224 POAVSS.t19 0 3.40741f
C225 POAVSS.t178 0 3.40752f
C226 POAVSS.t11 0 3.40196f
C227 POAVSS.t81 0 3.40196f
C228 POAVSS.t23 0 3.40196f
C229 POAVSS.t35 0 3.40196f
C230 POAVSS.t176 0 0.86263f
C231 POAVSS.t86 0 3.40196f
.ends
